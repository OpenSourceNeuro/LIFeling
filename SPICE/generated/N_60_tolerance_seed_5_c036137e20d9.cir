* LIFeling production SPICE validation deck
* authoritative_netlist=LIFeling.net
* netlist_sha256=d5a0bf3aa70e19a4470710342be6b2e11441efbc97374f23ff95af703fe9eeea
* netlist_export=2026-07-29T20:56:15
* kicad_tool=Eeschema 10.0.1
* source_lock_sha256=55df884890c53c1af35b7f03e638c13b9e68e5c5d7e3ac005e109ba13a78201c
* profile=hybrid
* test_name=60_tolerance_seed_5
* Connectivity is generated exclusively from physical pins in the KiCad export.
* Remaining approximations are enumerated in model_manifest.json and validation_report.md.
.option method=gear reltol=2e-4 abstol=1e-12 vntol=1e-7 chgtol=1e-14
.option itl1=1000 itl4=1000 gmin=1e-12
.temp 25
.include "../models/portable/lifeling_portable_models.lib"
.include "../models/compatible/MCP6001_ngspice.lib"

* --- physical sources and passives ---
VBT1_OC N_BT1_OC 0 DC 3
RBT1_INT N_BT1_OC P_BATT 20
RSW1 P_BATT VDD 150m
R_SW1_UNUSED unconnected_SW1_Pad3 0 1T
RR1 Net_U7_VOUT V_Boost 10.073569631
RR2 Vm_Out_DRV Vm_Ext 221.625013393
RR3 Vm_FB Vm_Out_DRV 10.0406200226k
RR4 0 Vm_FB 99.1598089016k
RR5 VREF_1V024_RAW VREF_2V048 218.115064978k
RR6 0 VREF_1V024_RAW 219.312887102k
RR7 V_Threshold VREF_1V024 20.0767416522k
RR8 V_Threshold 0 99.9530154961k
RR9 VREF_1V024 V_Reset_Ref 99.9981984105k
RR10 0 V_Reset_Ref 56.4167584767k
RR11 VDD V_Peak_Ref 99.16829071k
RR12 0 V_Peak_Ref 1.00868769241Meg
RR13 V_Logic_Mid VDD 218.128576089k
RR14 0 V_Logic_Mid 218.46624803k
RR15 Vm_Display_In Vm_Int 99.7201252932k
RR16 Net_U20_NO V_Peak_Drive 10.067374602k
RR17 VDD T4 100.922457144k
RR18 T4 T3 100.421017827k
RR19 T3 T2 99.404275768k
RR20 T2 T1 99.0233394872k
RR21 T1 0 100.011995731k
RR22 VDD S0 99.6310794389k
RR23 T1 S0 1.0022453801Meg
RR24 VDD S1 99.6259665654k
RR25 T1 S1 995.146608136k
RR26 T2 S1 995.582003042k
RR27 VDD S2 100.895460612k
RR28 T2 S2 992.446093029k
RR29 T3 S2 1.00843394959Meg
RR30 VDD S3 99.9480077489k
RR31 T3 S3 1.00893115055Meg
RR32 T4 S3 995.491155867k
RR33 VDD S4 100.589015753k
RR34 T4 S4 999.542082971k
RR35 Net_R35_Pad1 Vm_Int 1.00815182992k
RR36 V_Threshold N_AP_Gate 2.21935888775Meg
RR37 VDD N_AP_Gate 9.9983127986k
RR38 VDD AP 100.731611265k
RR39 0 N_Vkick 21.8039959899k
RR40 Net_R40_Pad1 0 99.2817204586
RR41 0 Net_U2C_VINDP 199.591415893k
RR42 Net_U2C_VINDP Vm_Int 100.106663583k
RR43 Net_U2C_VIND V_Leak 100.842724346k
RR44 Net_U2C_VIND N_Adapt 201.472659358k
RR45 N_Adapt Net_D6_A 330.558881188k
RR46 Vm_Int N_Adapt_Current_Sink 10.043341763k
RR47 N_Adapt_Base Vw_buff 21.8833910741k
RR48 N_Adapt_Base 0 99.3375745075k
RR49 N_Rising_AP 0 99.5782520321k
RR50 0 Spike_Pulse 1.00195733251Meg
RR51 VDD Peak_Window 100.194933334k
RR52 Net_U14_NO V_Peak_Drive 9.94471803986k
RR53 VDD Net_U6C_INC 21.8604372366k
RR54 N_Reset_Timer_Discharge Net_U6C_INC 99.8722375754
RR55 VDD Reset_Window 100.065097585k
RR56 Net_U6C_INCP VDD 269.263059103k
RR57 Net_U6C_INCP Reset_Window 1.00258347655Meg
RR58 0 Net_U6C_INCP 221.496509725k
RR59 VDD N_Reset_Injection_Enable 99.1912186548k
RR60 N_Reset_Gated_Drive Vm_Int 10.0844761068k
RR61 Net_Q7_D Net_D9_B 2.00944559952k
RR62 Net_Q7_D Net_D9_G 2.01470358097k
RR63 Net_Q8_Pad3 Net_D9_R 1.98997673415k
RR64 Net_Q8_Pad1 Vm_Int 10.0013186562k
RR65 Net_Q8_Pad1 0 99.4187486522k
RR66 Net_U15_NO V_Syn_State 22.1634210318k
RR67 Net_U15_IN Net_D10_A 997.592871955
RR68 0 Net_D10_A 100.146081263k
RR69 Syn1_Spike Net_D10_A 22.0518306071k
RR70 Net_U16_NO V_Syn_State 21.870527784k
RR71 Net_U16_IN Net_D12_A 992.243319335
RR72 0 Net_D12_A 100.923662918k
RR73 Syn2_Spike Net_D12_A 22.1449932912k
RR74 Net_U17_NO V_Syn_State 22.2146732662k
RR75 Net_U17_IN Net_D14_A 1.00571475758k
RR76 0 Net_D14_A 99.8388433099k
RR77 Syn3_Spike Net_D14_A 21.9287793745k
RR78 Net_U18_NO V_Syn_State 21.9598246737k
RR79 Net_U18_IN Net_D16_A 995.194584318
RR80 0 Net_D16_A 100.561640698k
RR81 Syn4_Spike Net_D16_A 21.9393468693k
RR82 V_Syn_State Net_R82_Pad2 10.0085752637k
RR83 V_Syn_State Net_U1C_VINDP 992.582933689k
RR84 Vm_Int Net_U1C_VINDP 1.0047886315Meg
RR85 VREF_1V024 Net_U1C_VIND 1.00791333042Meg
RR86 Net_U1C_VIND N_V_Syn_Drive 1.00423400574Meg
RR87 N_V_Syn_Drive Vm_Int 46.7079291219k
RR88 VDD Net_U19_OUT 99.622582236k
RR89 Net_U19_OUT Spike_Out 99.3198862048
RR90 VREF_1V024 V_Stim_Cmd 997.087172424k
RR91 Stimulus_Ext V_Stim_Cmd 996.742503605
RR92 Vm_Int Net_U23_INP 99.5291036762k
RR93 V_Stim_Cmd Net_U23_INP 199.795837072k
RR94 VREF_1V024 Net_U23_IN 201.201520811k
RR95 V_Stim_Drive Net_U23_IN 100.754282808k
RR96 V_Stim_Drive Vm_Int 99.1091076672k
* RV1: physical pin1=GNDREF, wiper=/V_Leak_ref, pin3=V_Leak_Ref_Max, fraction=0.55
RRV1_1W 0 N_V_Leak_ref 56.2915846507k
RRV1_W3 N_V_Leak_ref V_Leak_Ref_Max 46.0567510778k
* RV2: physical pin1=Net-(R35-Pad1), wiper=Vm_Int, pin3=V_Leak, fraction=0.5
RRV2_1W Net_R35_Pad1 Vm_Int 21.387084662k
RRV2_W3 Vm_Int V_Leak 21.387084662k
* RV3: physical pin1=Vw, wiper=Vw, pin3=Net-(R40-Pad1), fraction=0.5
RRV3_W3 Vw Net_R40_Pad1 48.7077691746k
* RV4: physical pin1=GNDREF, wiper=Vsel, pin3=VDD, fraction=0.1
RRV4_1W 0 Vsel 9.02953729534k
RRV4_W3 Vsel VDD 81.2658356581k
* RV5: physical pin1=Net-(R82-Pad2), wiper=Net-(R82-Pad2), pin3=VREF_1V024, fraction=0.5
RRV5_W3 Net_R82_Pad2 VREF_1V024 59.5732622289k
* RV6: physical pin1=GNDREF, wiper=Net-(U1D-VINA+), pin3=VREF_2V048, fraction=0.5
RRV6_1W 0 Net_U1D_VINAP 441.270055635k
RRV6_W3 Net_U1D_VINAP VREF_2V048 441.270055635k
* RV7: physical pin1=GNDREF, wiper=Net-(U1A-VINB+), pin3=VREF_2V048, fraction=0.5
RRV7_1W 0 Net_U1A_VINBP 463.430198928k
RRV7_W3 Net_U1A_VINBP VREF_2V048 463.430198928k
* RV8: physical pin1=GNDREF, wiper=Net-(U3B-VINC+), pin3=VREF_2V048, fraction=0.5
RRV8_1W 0 Net_U3B_VINCP 464.394934843k
RRV8_W3 Net_U3B_VINCP VREF_2V048 464.394934843k
* RV9: physical pin1=GNDREF, wiper=Net-(U3C-VIND+), pin3=VREF_2V048, fraction=0.5
RRV9_1W 0 Net_U3C_VINDP 414.349640314k
RRV9_W3 Net_U3C_VINDP VREF_2V048 414.349640314k
* C1 10uF; effective=9.321107e-06F, ESR=0.009596ohm, ESL=9e-10H, leakage=1.023e+08ohm
LC1_ESL P_BATT N_C1_ESL 900p
RC1_ESR N_C1_ESL N_C1_ESR 9.59556677746m
CC1 N_C1_ESR 0 9.32110687498u
RC1_LEAK N_C1_ESR 0 102.305446423Meg
* C2 10uF; effective=8.018661e-06F, ESR=0.01035ohm, ESL=9e-10H, leakage=1.189e+08ohm
LC2_ESL VDD N_C2_ESL 900p
RC2_ESR N_C2_ESL N_C2_ESR 10.3455465008m
CC2 N_C2_ESR 0 8.0186614463u
RC2_LEAK N_C2_ESR 0 118.922591555Meg
* C3 100nF; effective=9.832764e-08F, ESR=0.09391ohm, ESL=4.5e-10H, leakage=9.799e+09ohm
LC3_ESL 0 N_C3_ESL 450p
RC3_ESR N_C3_ESL N_C3_ESR 93.9094511376m
CC3 N_C3_ESR VDD 98.3276418687n
RC3_LEAK N_C3_ESR VDD 9.79887223662G
* C4 100nF; effective=9.650608e-08F, ESR=0.09479ohm, ESL=4.5e-10H, leakage=9.984e+09ohm
LC4_ESL 0 N_C4_ESL 450p
RC4_ESR N_C4_ESL N_C4_ESR 94.7915852054m
CC4 N_C4_ESR VDD 96.5060757833n
RC4_LEAK N_C4_ESR VDD 9.98382736195G
* C5 100nF; effective=1.004763e-07F, ESR=0.0929ohm, ESL=4.5e-10H, leakage=9.589e+09ohm
LC5_ESL 0 N_C5_ESL 450p
RC5_ESR N_C5_ESL N_C5_ESR 92.8999111464m
CC5 N_C5_ESR VDD 100.47629936n
RC5_LEAK N_C5_ESR VDD 9.58932610112G
* C6 100nF; effective=1.04691e-07F, ESR=0.09101ohm, ESL=4.5e-10H, leakage=9.203e+09ohm
LC6_ESL 0 N_C6_ESL 450p
RC6_ESR N_C6_ESL N_C6_ESR 91.0106763864m
CC6 N_C6_ESR VDD 104.691047295n
RC6_LEAK N_C6_ESR VDD 9.20327024034G
* C7 100nF; effective=9.258071e-08F, ESR=0.09678ohm, ESL=4.5e-10H, leakage=1.041e+10ohm
LC7_ESL 0 N_C7_ESL 450p
RC7_ESR N_C7_ESL N_C7_ESR 96.7802747871m
CC7 N_C7_ESR VDD 92.580714189n
RC7_LEAK N_C7_ESR VDD 10.4071350976G
* C8 100nF; effective=1.034802e-07F, ESR=0.09154ohm, ESL=4.5e-10H, leakage=9.311e+09ohm
LC8_ESL 0 N_C8_ESL 450p
RC8_ESR N_C8_ESL N_C8_ESR 91.5415904851m
CC8 N_C8_ESR VDD 103.480214639n
RC8_LEAK N_C8_ESR VDD 9.31095865393G
* C9 10uF; effective=7.737755e-06F, ESR=0.01053ohm, ESL=9e-10H, leakage=1.232e+08ohm
LC9_ESL VDD N_C9_ESL 900p
RC9_ESR N_C9_ESL N_C9_ESR 10.5316613396m
CC9 N_C9_ESR 0 7.7377551186u
RC9_LEAK N_C9_ESR 0 123.239878412Meg
* C10 22uF; effective=2.192594e-05F, ESR=0.008ohm, ESL=9e-10H, leakage=1e+08ohm
LC10_ESL 0 N_C10_ESL 900p
RC10_ESR N_C10_ESL N_C10_ESR 8m
CC10 N_C10_ESR Net_U7_VOUT 21.9259383053u
RC10_LEAK N_C10_ESR Net_U7_VOUT 100Meg
* C11 1uF; effective=9.435639e-07F, ESR=0.02945ohm, ESL=4.5e-10H, leakage=9.638e+08ohm
LC11_ESL V_Boost N_C11_ESL 450p
RC11_ESR N_C11_ESL N_C11_ESR 29.4525306072m
CC11 N_C11_ESR 0 943.563927402n
RC11_LEAK N_C11_ESR 0 963.835065743Meg
* C12 100nF; effective=9.841073e-08F, ESR=0.09387ohm, ESL=4.5e-10H, leakage=9.791e+09ohm
LC12_ESL V_Boost N_C12_ESL 450p
RC12_ESR N_C12_ESL N_C12_ESR 93.8697999917m
CC12 N_C12_ESR 0 98.4107277411n
RC12_LEAK N_C12_ESR 0 9.79059927831G
* C13 100pF; effective=1.002676e-10F, ESR=0.1ohm, ESL=4.5e-10H, leakage=1e+11ohm
LC13_ESL Vm_Ext N_C13_ESL 450p
RC13_ESR N_C13_ESL N_C13_ESR 100m
CC13 N_C13_ESR 0 100.267555937p
RC13_LEAK N_C13_ESR 0 100G
* C14 100nF; effective=1.022711e-07F, ESR=0.09208ohm, ESL=4.5e-10H, leakage=9.421e+09ohm
LC14_ESL V_Boost N_C14_ESL 450p
RC14_ESR N_C14_ESL N_C14_ESR 92.0811474987m
CC14 N_C14_ESR 0 102.271066041n
RC14_LEAK N_C14_ESR 0 9.4210419163G
* C15 100nF; effective=9.840245e-08F, ESR=0.09387ohm, ESL=4.5e-10H, leakage=9.791e+09ohm
LC15_ESL VREF_2V048 N_C15_ESL 450p
RC15_ESR N_C15_ESL N_C15_ESR 93.8737483838m
CC15 N_C15_ESR 0 98.4024494742n
RC15_LEAK N_C15_ESR 0 9.79142292848G
* C16 22nF; effective=2.264909e-08F, ESR=0.1957ohm, ESL=4.5e-10H, leakage=4.254e+10ohm
LC16_ESL 0 N_C16_ESL 450p
RC16_ESR N_C16_ESL N_C16_ESR 195.668878696m
CC16 N_C16_ESR Vm_Display_In 22.6490878321n
RC16_LEAK N_C16_ESR Vm_Display_In 42.5403445447G
* C17 100nF; effective=9.954676e-08F, ESR=0.09333ohm, ESL=4.5e-10H, leakage=9.679e+09ohm
LC17_ESL VDD N_C17_ESL 450p
RC17_ESR N_C17_ESL N_C17_ESR 93.3326421053m
CC17 N_C17_ESR 0 99.5467550962n
RC17_LEAK N_C17_ESR 0 9.6788689804G
* C18 470nF; effective=4.176202e-07F, ESR=0.04583ohm, ESL=6.5e-10H, leakage=2.334e+09ohm
LC18_ESL Net_U9_NO N_C18_ESL 650p
RC18_ESR N_C18_ESL N_C18_ESR 45.8321703017m
CC18 N_C18_ESR 0 417.620242089n
RC18_LEAK N_C18_ESR 0 2.33398648285G
* C19 100nF; effective=8.738644e-08F, ESR=0.09962ohm, ESL=4.5e-10H, leakage=1.103e+10ohm
LC19_ESL VDD N_C19_ESL 450p
RC19_ESR N_C19_ESL N_C19_ESR 99.6150784561m
CC19 N_C19_ESR 0 87.3864437391n
RC19_LEAK N_C19_ESR 0 11.0257376176G
* C20 1uF; effective=8.842953e-07F, ESR=0.03141ohm, ESL=6.5e-10H, leakage=1.096e+09ohm
LC20_ESL Net_U10_NO N_C20_ESL 650p
RC20_ESR N_C20_ESL N_C20_ESR 31.411094851m
CC20 N_C20_ESR 0 884.295257976n
RC20_LEAK N_C20_ESR 0 1.09628542193G
* C21 100nF; effective=9.462403e-08F, ESR=0.09573ohm, ESL=4.5e-10H, leakage=1.018e+10ohm
LC21_ESL VDD N_C21_ESL 450p
RC21_ESR N_C21_ESL N_C21_ESR 95.7296334084m
CC21 N_C21_ESR 0 94.6240291888n
RC21_LEAK N_C21_ESR 0 10.1824030139G
* C22 2.2uF; effective=2.213376e-06F, ESR=0.01965ohm, ESL=6.5e-10H, leakage=4.29e+08ohm
LC22_ESL Net_U11_NO N_C22_ESL 650p
RC22_ESR N_C22_ESL N_C22_ESR 19.6484101747m
CC22 N_C22_ESR 0 2.21337603077u
RC22_LEAK N_C22_ESR 0 428.955580435Meg
* C23 100nF; effective=9.227962e-08F, ESR=0.09694ohm, ESL=4.5e-10H, leakage=1.044e+10ohm
LC23_ESL VDD N_C23_ESL 450p
RC23_ESR N_C23_ESL N_C23_ESR 96.9380351497m
CC23 N_C23_ESR 0 92.2796211823n
RC23_LEAK N_C23_ESR 0 10.441091843G
* C24 4.7uF; effective=4.958594e-06F, ESR=0.01326ohm, ESL=9e-10H, leakage=1.955e+08ohm
LC24_ESL Net_U12_NO N_C24_ESL 900p
RC24_ESR N_C24_ESL N_C24_ESR 13.2648531592m
CC24 N_C24_ESR 0 4.95859400625u
RC24_LEAK N_C24_ESR 0 195.507032594Meg
* C25 100nF; effective=1.045169e-07F, ESR=0.09109ohm, ESL=4.5e-10H, leakage=9.219e+09ohm
LC25_ESL VDD N_C25_ESL 450p
RC25_ESR N_C25_ESL N_C25_ESR 91.0864659856m
CC25 N_C25_ESR 0 104.516900863n
RC25_LEAK N_C25_ESR 0 9.21860476194G
* C26 10uF; effective=9.992844e-06F, ESR=0.009344ohm, ESL=9e-10H, leakage=1e+08ohm
LC26_ESL Net_U13_NO N_C26_ESL 900p
RC26_ESR N_C26_ESL N_C26_ESR 9.34409316349m
CC26 N_C26_ESR 0 9.99284439792u
RC26_LEAK N_C26_ESR 0 100Meg
* C27 100nF; effective=9.154672e-08F, ESR=0.09733ohm, ESL=4.5e-10H, leakage=1.052e+10ohm
LC27_ESL VDD N_C27_ESL 450p
RC27_ESR N_C27_ESL N_C27_ESR 97.3252906877m
CC27 N_C27_ESR 0 91.5467243564n
RC27_LEAK N_C27_ESR 0 10.5246802305G
* C28 100pF; effective=1.043527e-10F, ESR=0.1ohm, ESL=4.5e-10H, leakage=1e+11ohm
LC28_ESL 0 N_C28_ESL 450p
RC28_ESR N_C28_ESL N_C28_ESR 100m
CC28 N_C28_ESR Vm_Int 104.35273652p
RC28_LEAK N_C28_ESR Vm_Int 100G
* C29 1uF; effective=8.827787e-07F, ESR=0.03144ohm, ESL=6.5e-10H, leakage=1.098e+09ohm
LC29_ESL N_Vkick N_C29_ESL 650p
RC29_ESR N_C29_ESL N_C29_ESR 31.438063774m
CC29 N_C29_ESR N_Adapt_Kick_Drive 882.778735724n
RC29_LEAK N_C29_ESR N_Adapt_Kick_Drive 1.09816872651G
* C30 10uF; effective=7.747492e-06F, ESR=0.01053ohm, ESL=9e-10H, leakage=1.231e+08ohm
LC30_ESL 0 N_C30_ESL 900p
RC30_ESR N_C30_ESL N_C30_ESR 10.5250415264m
CC30 N_C30_ESR Vw 7.74749163158u
RC30_LEAK N_C30_ESR Vw 123.084999035Meg
* C31 10nF; effective=1.041333e-08F, ESR=0.2886ohm, ESL=4.5e-10H, leakage=9.253e+10ohm
LC31_ESL AP N_C31_ESL 450p
RC31_ESR N_C31_ESL N_C31_ESR 288.570716706m
CC31 N_C31_ESR N_Rising_AP 10.4133319371n
RC31_LEAK N_C31_ESR N_Rising_AP 92.5256206002G
* C32 100nF; effective=8.938316e-08F, ESR=0.0985ohm, ESL=4.5e-10H, leakage=1.078e+10ohm
LC32_ESL VDD N_C32_ESL 450p
RC32_ESR N_C32_ESL N_C32_ESR 98.4961542361m
CC32 N_C32_ESR 0 89.3831551176n
RC32_LEAK N_C32_ESR 0 10.7794359992G
* C33 1uF; effective=9.02223e-07F, ESR=0.0311ohm, ESL=4.5e-10H, leakage=1.075e+09ohm
LC33_ESL 0 N_C33_ESL 450p
RC33_ESR N_C33_ESL N_C33_ESR 31.0974500317m
CC33 N_C33_ESR Net_U6C_INC 902.222985643n
RC33_LEAK N_C33_ESR Net_U6C_INC 1.07450155386G
* C34 100nF; effective=9.171453e-08F, ESR=0.09724ohm, ESL=4.5e-10H, leakage=1.051e+10ohm
LC34_ESL VDD N_C34_ESL 450p
RC34_ESR N_C34_ESL N_C34_ESR 97.2362166376m
CC34 N_C34_ESR 0 91.7145254651n
RC34_LEAK N_C34_ESR 0 10.5054242511G
* C35 100nF; effective=1.016099e-07F, ESR=0.09238ohm, ESL=4.5e-10H, leakage=9.482e+09ohm
LC35_ESL VDD N_C35_ESL 450p
RC35_ESR N_C35_ESL N_C35_ESR 92.3802615533m
CC35 N_C35_ESR 0 101.609860097n
RC35_LEAK N_C35_ESR 0 9.48234747184G
* C36 100nF; effective=1.049807e-07F, ESR=0.09089ohm, ESL=4.5e-10H, leakage=9.178e+09ohm
LC36_ESL VDD N_C36_ESL 450p
RC36_ESR N_C36_ESL N_C36_ESR 90.8850280296m
CC36 N_C36_ESR 0 104.980717689n
RC36_LEAK N_C36_ESR 0 9.17787591105G
* C37 100nF; effective=9.53299e-08F, ESR=0.09537ohm, ESL=4.5e-10H, leakage=1.011e+10ohm
LC37_ESL VDD N_C37_ESL 450p
RC37_ESR N_C37_ESL N_C37_ESR 95.3745602734m
CC37 N_C37_ESR 0 95.3298986155n
RC37_LEAK N_C37_ESR 0 10.107007497G
* C38 220nF; effective=1.935706e-07F, ESR=0.06693ohm, ESL=6.5e-10H, leakage=4.978e+09ohm
LC38_ESL 0 N_C38_ESL 650p
RC38_ESR N_C38_ESL N_C38_ESR 66.9310105611m
CC38 N_C38_ESR V_Syn_State 193.570630163n
RC38_LEAK N_C38_ESR V_Syn_State 4.97751130526G
* C39 100pF; effective=1.005111e-10F, ESR=0.1ohm, ESL=4.5e-10H, leakage=1e+11ohm
LC39_ESL V_Stim_Cmd N_C39_ESL 450p
RC39_ESR N_C39_ESL N_C39_ESR 100m
CC39 N_C39_ESR 0 100.511136967p
RC39_LEAK N_C39_ESR 0 100G
* C40 100nF; effective=1.012718e-07F, ESR=0.09253ohm, ESL=4.5e-10H, leakage=9.514e+09ohm
LC40_ESL VDD N_C40_ESL 450p
RC40_ESR N_C40_ESL N_C40_ESR 92.5343175805m
CC40 N_C40_ESR 0 101.271810791n
RC40_LEAK N_C40_ESR 0 9.51399992232G
* C41 100nF; effective=9.697385e-08F, ESR=0.09456ohm, ESL=4.5e-10H, leakage=9.936e+09ohm
LC41_ESL 0 N_C41_ESL 450p
RC41_ESR N_C41_ESL N_C41_ESR 94.5626845132m
CC41 N_C41_ESR VDD 96.973851076n
RC41_LEAK N_C41_ESR VDD 9.93566811372G
* C42 100nF; effective=9.844576e-08F, ESR=0.09385ohm, ESL=4.5e-10H, leakage=9.787e+09ohm
LC42_ESL 0 N_C42_ESL 450p
RC42_ESR N_C42_ESL N_C42_ESR 93.8530969507m
CC42 N_C42_ESR VDD 98.4457591838n
RC42_LEAK N_C42_ESR VDD 9.78711534137G
* C43 100nF; effective=1.001235e-07F, ESR=0.09306ohm, ESL=4.5e-10H, leakage=9.623e+09ohm
LC43_ESL 0 N_C43_ESL 450p
RC43_ESR N_C43_ESL N_C43_ESR 93.0634488212m
CC43 N_C43_ESR VDD 100.123481511n
RC43_LEAK N_C43_ESR VDD 9.62311722944G
* L1 ANR3015T2R2M: datasheet-derived DCR=85mohm, Cp=12pF, Isat gate=2A
RL1_DCR VDD N_L1_DCR 85m
LL1 N_L1_DCR Net_U7_SW 2.03383534105u
CL1_PAR VDD Net_U7_SW 12p

* --- physical active devices ---
XU1A Net_U1D_VINAP V_Syn1_Set VDD 0 V_Syn1_Set MCP6001
XU1B Net_U1A_VINBP V_Syn2_Set VDD 0 V_Syn2_Set MCP6001
XU1C Vw Vw_buff VDD 0 Vw_buff MCP6001
XU1D Net_U1C_VINDP Net_U1C_VIND VDD 0 N_V_Syn_Drive MCP6001
XU2A AP N_Adapt_Kick_Drive VDD 0 N_Adapt_Kick_Drive MCP6001
XU2B V_Reset_Ref N_Reset_Injection_Drive VDD 0 N_Reset_Injection_Drive MCP6001
XU2C V_Peak_Ref V_Peak_Drive VDD 0 V_Peak_Drive MCP6001
XU2D Net_U2C_VINDP Net_U2C_VIND VDD 0 N_Adapt MCP6001
XU3A N_V_Leak_ref V_Leak VDD 0 V_Leak MCP6001
XU3B VREF_2V048 V_Leak_Ref_Max VDD 0 V_Leak_Ref_Max MCP6001
XU3C Net_U3B_VINCP V_Syn3_Set VDD 0 V_Syn3_Set MCP6001
XU3D Net_U3C_VINDP V_Syn4_Set VDD 0 V_Syn4_Set MCP6001
XU4A S0 0 T1 Vsel VDD LIF_TLV7041_OD
XU4B S1 0 Vsel T1 VDD LIF_TLV7041_OD
XU4C S1 0 T2 Vsel VDD LIF_TLV7041_OD
XU4D S4 0 Vsel T4 VDD LIF_TLV7041_OD
XU5A S2 0 Vsel T2 VDD LIF_TLV7041_OD
XU5B S2 0 T3 Vsel VDD LIF_TLV7041_OD
XU5C S3 0 Vsel T3 VDD LIF_TLV7041_OD
XU5D S3 0 T4 Vsel VDD LIF_TLV7041_OD
XU6A Peak_Window 0 Spike_Pulse V_Threshold VDD LIF_TLV7041_OD
XU6B unconnected_U6B_OUTB_Pad7 0 VDD 0 VDD LIF_TLV7041_OD
XU6C Reset_Window 0 Net_U6C_INCP Net_U6C_INC VDD LIF_TLV7041_OD
XU6D N_AP_Gate 0 V_Threshold Vm_Int VDD LIF_TLV7041_OD
XU7 0 Net_U7_VOUT 0 VDD Net_U7_SW VDD LIF_TPS610995_SWITCHING
RU7_PAD 0 0 1u
XU8 Vm_Display_In Vm_FB V_Boost 0 Vm_Out_DRV LIF_TLV9001
XU9 Net_U9_NO Vm_Int 0 S0 VDD LIF_TS5A3166
XU10 Net_U10_NO Vm_Int 0 S1 VDD LIF_TS5A3166
XU11 Net_U11_NO Vm_Int 0 S2 VDD LIF_TS5A3166
XU12 Net_U12_NO Vm_Int 0 S3 VDD LIF_TS5A3166
XU13 Net_U13_NO Vm_Int 0 S4 VDD LIF_TS5A3166
XU14 Net_U14_NO Vm_Int 0 Peak_Window VDD LIF_TS5A3166
XU15 Net_U15_NO V_Syn1_Set 0 Net_U15_IN VDD LIF_TS5A3166
XU16 Net_U16_NO V_Syn2_Set 0 Net_U16_IN VDD LIF_TS5A3166
XU17 Net_U17_NO V_Syn3_Set 0 Net_U17_IN VDD LIF_TS5A3166
XU18 Net_U18_NO V_Syn4_Set 0 Net_U18_IN VDD LIF_TS5A3166
XU19 Net_U19_OUT 0 Peak_Window V_Logic_Mid VDD LIF_TLV7031_PP
XU20 Net_U20_NO Vm_Display_In 0 Peak_Window VDD LIF_TS5A3166
XU21 VDD VREF_2V048 0 LIF_REF3020
XU22 VREF_1V024_RAW VREF_1V024 VDD 0 VREF_1V024 LIF_TLV9001
XU23 Net_U23_INP Net_U23_IN VDD 0 V_Stim_Drive LIF_TLV9041
XD1 Vm_Ext 0 LIF_TPD1E05U06
DD2 Vm_Int VDD LIF_BAT54WS
DD3 0 Vm_Int LIF_BAT54WS
DD4 0 N_Vkick LIF_1N4148WS
DD5 N_Vkick Vw LIF_1N4148WS
DD6 Net_D6_A Vw LIF_RB521S30
DD7 0 Vw LIF_1N4148WS
DD8 N_Rising_AP Spike_Pulse LIF_RB521S30
DD9_R VDD Net_D9_R LIF_LED_RED
DD9_G VDD Net_D9_G LIF_LED_GREEN
DD9_B VDD Net_D9_B LIF_LED_BLUE
DD10 Net_D10_A VDD LIF_BAT54WS
DD11 0 Net_D10_A LIF_BAT54WS
DD12 Net_D12_A VDD LIF_BAT54WS
DD13 0 Net_D12_A LIF_BAT54WS
DD14 Net_D14_A VDD LIF_BAT54WS
DD15 0 Net_D14_A LIF_BAT54WS
DD16 Net_D16_A VDD LIF_BAT54WS
DD17 0 Net_D16_A LIF_BAT54WS
XD18 Spike_Out 0 LIF_TPD1E05U06
XD19 Stimulus_Ext 0 LIF_TPD1E05U06
DD20 0 Spike_Pulse LIF_RB521S30
DD21 Vm_Display_In VDD LIF_BAT54WS
DD22 0 Vm_Display_In LIF_BAT54WS
MQ1 AP N_AP_Gate 0 0 LIF_BSS138
QQ2 N_Adapt_Current_Sink N_Adapt_Base 0 LIF_MMBT3904
MQ3 N_Reset_Timer_Discharge AP 0 0 LIF_BSS138
MQ4 N_Reset_Injection_Enable Peak_Window 0 0 LIF_BSS138
MQ5 N_Reset_Switch_Mid N_Reset_Injection_Enable N_Reset_Injection_Drive N_Reset_Injection_Drive LIF_BSS138
MQ6 N_Reset_Gated_Drive Reset_Window N_Reset_Switch_Mid N_Reset_Switch_Mid LIF_BSS138
MQ7 Net_Q7_D Reset_Window 0 0 LIF_BSS138
QQ8 Net_Q8_Pad3 Net_Q8_Pad1 0 LIF_MMBT3904

* --- external terminals ---
R_EXT_STIM_FLOAT Stimulus_Ext 0 1T
R_EXT_SYN1_FLOAT Syn1_Spike 0 1T
R_EXT_SYN2_FLOAT Syn2_Spike 0 1T
R_EXT_SYN3_FLOAT Syn3_Spike 0 1T
R_EXT_SYN4_FLOAT Syn4_Spike 0 1T
* J1 Stim_Ext: pin1=Vm_Ext, pin2=Stimulus_Ext, pin3=GNDREF
* J2 Axon_Output: pin1=Vm_Ext, pin2=Spike_Out, pin3=GNDREF
* J3 Syn1_Input: pin1=unconnected-(J3-Pad1), pin2=Syn1_Spike, pin3=GNDREF
* J4 Syn2_Input: pin1=unconnected-(J4-Pad1), pin2=Syn2_Spike, pin3=GNDREF
* J5 Syn3_Input: pin1=unconnected-(J5-Pad1), pin2=Syn3_Spike, pin3=GNDREF
* J6 Syn4_Input: pin1=unconnected-(J6-Pad1), pin2=Syn4_Spike, pin3=GNDREF
* H1: mechanical-only mounting hole
* H2: mechanical-only mounting hole
* H3: mechanical-only mounting hole
* H4: mechanical-only mounting hole
* H5: mechanical-only mounting hole
* H6: mechanical-only mounting hole
R_FLOAT_unconnected_J3_Pad1 unconnected_J3_Pad1 0 1T
R_FLOAT_unconnected_J4_Pad1 unconnected_J4_Pad1 0 1T
R_FLOAT_unconnected_J5_Pad1 unconnected_J5_Pad1 0 1T
R_FLOAT_unconnected_J6_Pad1 unconnected_J6_Pad1 0 1T
R_FLOAT_unconnected_SW1_Pad3 unconnected_SW1_Pad3 0 1T
R_FLOAT_unconnected_U6B_OUTB_Pad7 unconnected_U6B_OUTB_Pad7 0 1T

* --- analysis ---
.save v(VDD) v(V_Boost) v(VREF_2V048) v(VREF_1V024) v(V_Leak) v(Vm_Int) v(V_Threshold) v(AP) v(Spike_Pulse) v(Peak_Window) v(Reset_Window) v(Vm_Display_In) v(Vm_Ext) v(Spike_Out) v(V_Syn_State) v(N_V_Syn_Drive) v(V_Stim_Cmd) v(V_Stim_Drive) v(Vsel) v(S0) v(S1) v(S2) v(S3) v(S4) v(Vw) v(Vw_buff) v(N_Vkick) v(N_Adapt_Kick_Drive) v(N_Rising_AP) v(N_AP_Gate) v(V_Reset_Ref) v(N_Reset_Injection_Drive) v(N_Reset_Gated_Drive) v(V_Peak_Drive) v(V_Syn1_Set) v(V_Syn2_Set) v(V_Syn3_Set) v(V_Syn4_Set)
.tran 10u 250m 0 10u uic
.control
run
wrdata N_60_tolerance_seed_5.wrdata.txt v(VDD) v(V_Boost) v(VREF_2V048) v(VREF_1V024) v(V_Leak) v(Vm_Int) v(V_Threshold) v(AP) v(Spike_Pulse) v(Peak_Window) v(Reset_Window) v(Vm_Display_In) v(Vm_Ext) v(Spike_Out) v(V_Syn_State) v(N_V_Syn_Drive) v(V_Stim_Cmd) v(V_Stim_Drive) v(Vsel) v(S0) v(S1) v(S2) v(S3) v(S4) v(Vw) v(Vw_buff) v(N_Vkick) v(N_Adapt_Kick_Drive) v(N_Rising_AP) v(N_AP_Gate) v(V_Reset_Ref) v(N_Reset_Injection_Drive) v(N_Reset_Gated_Drive) v(V_Peak_Drive) v(V_Syn1_Set) v(V_Syn2_Set) v(V_Syn3_Set) v(V_Syn4_Set)
quit
.endc
.end
