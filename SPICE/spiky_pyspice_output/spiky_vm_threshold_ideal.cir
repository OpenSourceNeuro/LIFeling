* Spiky_Lui2 Vm simulation: stage=threshold
* Generated by spiky_lui2_vm_groundtruth.py
* KiCad GNDREF is mapped to ngspice ground node 0.
.option method=gear reltol=1e-4 abstol=1e-12 vntol=1e-6 chgtol=1e-14
.option itl1=500 itl4=500
.temp 25

* ---- Fallback models: replace with vendor models for final analysis ----
.model D1N4148_FALLBACK D(Is=2.52n Rs=0.568 N=1.752 Cjo=2p M=0.4 Eg=1.11 Tt=4n)
.model RB521S30_FALLBACK D(Is=5u Rs=1 N=1.05 Cjo=10p Eg=0.69 Bv=30 Ibv=10u)
.model MMBT3904_FALLBACK NPN(Is=6.7f Bf=250 Vaf=100 Ikf=0.1 Xtb=1.5 Br=6 Cjc=4p Cje=8p Tf=300p Tr=50n)
.model BSS138_FALLBACK NMOS(Level=1 Vto=1.2 Kp=2m Lambda=0.02 Rd=2 Rs=2 Cgd=20p Cgs=20p)
.model SW_OC SW(Ron=10 Roff=1e12 Vt=0 Vh=1m)

* ---- Supply and reference dividers ----
VDD VDD 0 DC 3
CDEC1 VDD 0 100n
CDEC2 VDD 0 10u

* Ground-truth divider: R4=49.9k VDD->V_Leak_Ref_Max, R5=100k V_Leak_Ref_Max->GNDREF
R4 VDD V_Leak_Ref_Max 49.9k
R5 V_Leak_Ref_Max 0 100k

* RV1=50k: pin1=GNDREF, pin2=/V_Leak_ref, pin3=V_Leak_Ref_Max; fraction=1.000
RV1_LOW V_Leak_ref 0 49999.95
RV1_HIGH V_Leak_Ref_Max V_Leak_ref 0.0500000000014
EU1A V_Leak 0 V_Leak_ref 0 1

* Reset injection reference: R10=69.8k VDD->V_Reset_Ref, R11=10k V_Reset_Ref->GNDREF
R10 VDD V_Reset_Ref 69.8k
R11 V_Reset_Ref 0 10k
EU2B Reset_Injection_Drive 0 V_Reset_Ref 0 1

* ---- Passive membrane core ----
* RV2 ground truth: pin1=Net-(R32-Pad1), pin2=Vm_Int, pin3=V_Leak, R32=1k pin1->Vm_Int.
RV2_LOWER RV2_pin1 Vm_Int 25000
R32 RV2_pin1 Vm_Int 1k
RV2_UPPER V_Leak Vm_Int 25000
CMEM_SELECTED Vm_Int 0 2.2u IC=0.385
C26 Vm_Int 0 100p

* ---- Threshold comparator U6B and AP/spike generation ----
* Ground truth: R6=24.3k VDD->V_Threshold, R7=10k V_Threshold->GNDREF.
R6 VDD V_Threshold 24.3k
R7 V_Threshold 0 10k
* U6B: INB+=V_Threshold, INB-=Vm_Int, OUTB=Net-(Q1-G).
R33 V_Threshold Q1_G 220k
R34 VDD Q1_G 10k
SU6B Q1_G 0 Vm_Int V_Threshold SW_OC
* Q1=BSS138: D=AP, G=Net-(Q1-G), S=GNDREF.
R35 VDD AP 22k
MQ1 AP Q1_G 0 0 BSS138_FALLBACK
* C29=10nF AP->/Rising_AP, R46=100k /Rising_AP->GNDREF, D8=RB521S30T1G to Spike_Pulse.
C29 AP Rising_AP 10n
R46 Rising_AP 0 100k
DD8 Rising_AP Spike_Pulse RB521S30_FALLBACK
R47 Spike_Pulse 0 1Meg

* ---- Analysis ----
.tran 1u 0.15 0 1u uic
.save V(Vm_Int) V(V_Leak) V(V_Leak_ref) V(V_Leak_Ref_Max) V(V_Reset_Ref) V(Reset_Injection_Drive) V(V_Threshold) V(Q1_G) V(AP) V(Rising_AP) V(Spike_Pulse)
.control
run
wrdata C:/Users/mjyzi/Documents/GitHub/Spiky-Lu.i/spiky_pyspice_output/spiky_vm_threshold_ideal.csv v(Vm_Int) v(V_Leak) v(V_Leak_ref) v(V_Leak_Ref_Max) v(V_Reset_Ref) v(Reset_Injection_Drive) v(V_Threshold) v(Q1_G) v(AP) v(Rising_AP) v(Spike_Pulse)
quit
.endc
.end
