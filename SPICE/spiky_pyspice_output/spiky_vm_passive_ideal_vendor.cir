* Spiky_Lui2 Vm simulation: stage=passive
* Generated by spiky_lui2_vm_pyspice_vendor_models.py
.option method=gear reltol=1e-4 abstol=1e-12 vntol=1e-6 chgtol=1e-14
.option itl1=500 itl4=500
.temp 25

.include "C:/Users/mjyzi/Documents/GitHub/Spiky-Lu.i/spiky_pyspice_output/patched_models/MCP6001_ngspice.lib"

* ---- Local wrappers around vendor macromodels ----
* MCP6004_UNIT wrapper API: OUT MINUS PLUS VDD VSS
.subckt MCP6004_UNIT OUT MINUS PLUS VDD VSS
* Default assumed vendor order below: PLUS MINUS VDD VSS OUT
XAMP PLUS MINUS VDD VSS OUT MCP6001
.ends MCP6004_UNIT

* ---- Supply and references ----
VDD VDD 0 DC 3
CDEC1 VDD 0 100n
CDEC2 VDD 0 10u

* +2V divider from extracted R3=1k, R4=2k
R3 VDD PLUS2 1k
R4 PLUS2 0 2k

* RV1 = 100k, wiper fraction = 0.500: lower=50000 ohm, upper=50000 ohm
RV1_LOW VREF 0 50000
RV1_HIGH PLUS2 VREF 50000
XU1A VLEAK VLEAK VREF VDD 0 MCP6004_UNIT

* +0.375V nominal divider from R1=6.8k, R2=1k; exact value scales with VDD
R1 VDD V0375 6.8k
R2 V0375 0 1k
XU1B RESET_INJ RESET_INJ V0375 VDD 0 MCP6004_UNIT

* ---- Passive membrane core ----
* RV2 = 50k used as rheostat with pins 1/2 tied to Vm: Rleak=25000 ohm
RV2_LEAK VLEAK VM 25000
CMEM VM 0 2.2u IC=0.385

* ---- Analysis ----
.tran 10u 1 0 10u uic
.save V(VM) V(VLEAK) V(VREF)
.control
run
wrdata C:/Users/mjyzi/Documents/GitHub/Spiky-Lu.i/spiky_pyspice_output/spiky_vm_passive_ideal_vendor.csv v(VM) v(VLEAK) v(VREF)
quit
.endc
.end
