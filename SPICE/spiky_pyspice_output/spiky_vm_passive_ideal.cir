* Spiky_Lui2 Vm simulation: stage=passive
* Generated by spiky_lui2_vm_groundtruth.py
* KiCad GNDREF is mapped to ngspice ground node 0.
.option method=gear reltol=1e-4 abstol=1e-12 vntol=1e-6 chgtol=1e-14
.option itl1=500 itl4=500
.temp 25

* ---- Fallback models: replace with vendor models for final analysis ----
.model D1N4148_FALLBACK D(Is=2.52n Rs=0.568 N=1.752 Cjo=2p M=0.4 Eg=1.11 Tt=4n)
.model RB521S30_FALLBACK D(Is=5u Rs=1 N=1.05 Cjo=10p Eg=0.69 Bv=30 Ibv=10u)
.model MMBT3904_FALLBACK NPN(Is=6.7f Bf=250 Vaf=100 Ikf=0.1 Xtb=1.5 Br=6 Cjc=4p Cje=8p Tf=300p Tr=50n)
.model BSS138_FALLBACK NMOS(Level=1 Vto=1.2 Kp=2m Lambda=0.02 Rd=2 Rs=2 Cgd=20p Cgs=20p)
.model SW_OC SW(Ron=10 Roff=1e12 Vt=0 Vh=1m)

* ---- Supply and reference dividers ----
VDD VDD 0 DC 3
CDEC1 VDD 0 100n
CDEC2 VDD 0 10u

* Ground-truth divider: R4=49.9k VDD->V_Leak_Ref_Max, R5=100k V_Leak_Ref_Max->GNDREF
R4 VDD V_Leak_Ref_Max 49.9k
R5 V_Leak_Ref_Max 0 100k

* RV1=50k: pin1=GNDREF, pin2=/V_Leak_ref, pin3=V_Leak_Ref_Max; fraction=0.500
RV1_LOW V_Leak_ref 0 25000
RV1_HIGH V_Leak_Ref_Max V_Leak_ref 25000
EU1A V_Leak 0 V_Leak_ref 0 1

* Reset injection reference: R10=69.8k VDD->V_Reset_Ref, R11=10k V_Reset_Ref->GNDREF
R10 VDD V_Reset_Ref 69.8k
R11 V_Reset_Ref 0 10k
EU2B Reset_Injection_Drive 0 V_Reset_Ref 0 1

* ---- Passive membrane core ----
* RV2 ground truth: pin1=Net-(R32-Pad1), pin2=Vm_Int, pin3=V_Leak, R32=1k pin1->Vm_Int.
RV2_LOWER RV2_pin1 Vm_Int 25000
R32 RV2_pin1 Vm_Int 1k
RV2_UPPER V_Leak Vm_Int 25000
CMEM_SELECTED Vm_Int 0 2.2u IC=0.385
C26 Vm_Int 0 100p

* ---- Analysis ----
.tran 10u 1 0 10u uic
.save V(Vm_Int) V(V_Leak) V(V_Leak_ref) V(V_Leak_Ref_Max) V(V_Reset_Ref) V(Reset_Injection_Drive)
.control
run
wrdata C:/Users/mjyzi/Documents/GitHub/Spiky-Lu.i/spiky_pyspice_output/spiky_vm_passive_ideal.csv v(Vm_Int) v(V_Leak) v(V_Leak_ref) v(V_Leak_Ref_Max) v(V_Reset_Ref) v(Reset_Injection_Drive)
quit
.endc
.end
