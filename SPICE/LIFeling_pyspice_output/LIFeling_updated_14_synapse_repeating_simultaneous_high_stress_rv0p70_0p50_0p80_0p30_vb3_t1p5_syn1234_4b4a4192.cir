* LIFeling full-schematic behavioural model
* Source netlist: C:\Users\mjyzi\Documents\GitHub\LIFeling\SPICE\LIFeling.net
* Generated by Spice.py validation-suite-v4
.option method=gear reltol=1e-4 abstol=1e-12 vntol=1e-6 chgtol=1e-14
.option itl1=500 itl4=500
.option gmin=1e-12
.temp 25

* -----------------------------------------------------------------------------
* Generic fallback device models
* -----------------------------------------------------------------------------
.model BSS138_FALLBACK NMOS(Level=1 Vto=1.2 Kp=2m Lambda=0.02 Rd=2 Rs=2)
.model MMBT3904_FALLBACK NPN(Is=6.7f Bf=250 Vaf=100 Ikf=0.1 Br=6 Cjc=4p Cje=8p Tf=300p Tr=50n)
.model D1N4148_FALLBACK D(Is=2.52n Rs=0.568 N=1.752 Cjo=2p M=0.4 Tt=4n)
.model RB521S30_FALLBACK D(Is=5u Rs=1 N=1.05 Cjo=10p Eg=0.69 Bv=30 Ibv=10u)
.model BAT54_FALLBACK D(Is=2u Rs=1 N=1.05 Cjo=10p Eg=0.69 Bv=30 Ibv=10u)
.model LED_RED_FALLBACK D(Is=10n Rs=20 N=2.0 Eg=1.8 Cjo=5p)
.model LED_GREEN_FALLBACK D(Is=10n Rs=20 N=2.2 Eg=2.1 Cjo=5p)
.model LED_BLUE_FALLBACK D(Is=10n Rs=20 N=2.8 Eg=2.7 Cjo=5p)
.model SW_TS5A3166 SW(Ron=0.9 Roff=1e12 Vt=1.5 Vh=0.05)
.model SW_OC SW(Ron=5 Roff=1e12 Vt=0 Vh=1m)

* -----------------------------------------------------------------------------
* KiCad-net to SPICE-node aliases
* -----------------------------------------------------------------------------
* +BATT  ->  P_BATT
* /AP_Gate  ->  N_AP_Gate
* /Adapt_Base  ->  N_Adapt_Base
* /Adapt_Current_Sink  ->  N_Adapt_Current_Sink
* /Adapt_Kick_Drive  ->  N_Adapt_Kick_Drive
* /Reset_Gated_Drive  ->  N_Reset_Gated_Drive
* /Reset_Injection_Drive  ->  N_Reset_Injection_Drive
* /Reset_Injection_Enable  ->  N_Reset_Injection_Enable
* /Reset_Switch_Mid  ->  N_Reset_Switch_Mid
* /Reset_Timer_Discharge  ->  N_Reset_Timer_Discharge
* /Rising_AP  ->  N_Rising_AP
* /V_Leak_ref  ->  N_V_Leak_ref
* /V_Syn_Drive  ->  N_V_Syn_Drive
* /Vkick  ->  N_Vkick
* AP  ->  AP
* GNDREF  ->  0
* Net-(D10-A)  ->  Net_D10_A
* Net-(D12-A)  ->  Net_D12_A
* Net-(D14-A)  ->  Net_D14_A
* Net-(D16-A)  ->  Net_D16_A
* Net-(D6-A)  ->  Net_D6_A
* Net-(D9-B-)  ->  Net_D9_B
* Net-(D9-G-)  ->  Net_D9_G
* Net-(D9-R-)  ->  Net_D9_R
* Net-(Q7-D)  ->  Net_Q7_D
* Net-(Q8-Pad1)  ->  Net_Q8_Pad1
* Net-(Q8-Pad3)  ->  Net_Q8_Pad3
* Net-(R35-Pad1)  ->  Net_R35_Pad1
* Net-(R40-Pad1)  ->  Net_R40_Pad1
* Net-(R82-Pad2)  ->  Net_R82_Pad2
* Net-(U10-NO)  ->  Net_U10_NO
* Net-(U11-NO)  ->  Net_U11_NO
* Net-(U12-NO)  ->  Net_U12_NO
* Net-(U13-NO)  ->  Net_U13_NO
* Net-(U14-NO)  ->  Net_U14_NO
* Net-(U15-IN)  ->  Net_U15_IN
* Net-(U15-NO)  ->  Net_U15_NO
* Net-(U16-IN)  ->  Net_U16_IN
* Net-(U16-NO)  ->  Net_U16_NO
* Net-(U17-IN)  ->  Net_U17_IN
* Net-(U17-NO)  ->  Net_U17_NO
* Net-(U18-IN)  ->  Net_U18_IN
* Net-(U18-NO)  ->  Net_U18_NO
* Net-(U19-OUT)  ->  Net_U19_OUT
* Net-(U1A-VINB+)  ->  Net_U1A_VINBP
* Net-(U1A-VINB-)  ->  Net_U1A_VINB
* Net-(U1A-VOUTB)  ->  Net_U1A_VOUTB
* Net-(U20-NO)  ->  Net_U20_NO
* Net-(U2C-VIND+)  ->  Net_U2C_VINDP
* Net-(U2C-VIND-)  ->  Net_U2C_VIND
* Net-(U3A-VINB+)  ->  Net_U3A_VINBP
* Net-(U3B-VINC+)  ->  Net_U3B_VINCP
* Net-(U3C-VIND+)  ->  Net_U3C_VINDP
* Net-(U3D-VINA+)  ->  Net_U3D_VINAP
* Net-(U6B-INB+)  ->  Net_U6B_INBP
* Net-(U6B-INB-)  ->  Net_U6B_INB
* Net-(U6C-INC+)  ->  Net_U6C_INCP
* Net-(U6C-INC-)  ->  Net_U6C_INC
* Net-(U7-SW)  ->  Net_U7_SW
* Net-(U7-VOUT)  ->  Net_U7_VOUT
* Net-(U9-NO)  ->  Net_U9_NO
* Peak_Window  ->  Peak_Window
* Reset_Window  ->  Reset_Window
* S0  ->  S0
* S1  ->  S1
* S2  ->  S2
* S3  ->  S3
* S4  ->  S4
* Spike_Out  ->  Spike_Out
* Spike_Pulse  ->  Spike_Pulse
* Stimulus_Ext  ->  Stimulus_Ext
* Syn1_Spike  ->  Syn1_Spike
* Syn2_Spike  ->  Syn2_Spike
* Syn3_Spike  ->  Syn3_Spike
* Syn4_Spike  ->  Syn4_Spike
* T1  ->  T1
* T2  ->  T2
* T3  ->  T3
* T4  ->  T4
* VDD  ->  VDD
* VREF_1V024  ->  VREF_1V024
* VREF_1V024_RAW  ->  VREF_1V024_RAW
* VREF_2V048  ->  VREF_2V048
* V_Boost  ->  V_Boost
* V_Leak  ->  V_Leak
* V_Leak_Ref_Max  ->  V_Leak_Ref_Max
* V_Logic_Mid  ->  V_Logic_Mid
* V_Peak_Drive  ->  V_Peak_Drive
* V_Peak_Ref  ->  V_Peak_Ref
* V_Reset_Ref  ->  V_Reset_Ref
* V_Stim_Cmd  ->  V_Stim_Cmd
* V_Stim_Drive  ->  V_Stim_Drive
* V_Syn1_Set  ->  V_Syn1_Set
* V_Syn2_Set  ->  V_Syn2_Set
* V_Syn3_Set  ->  V_Syn3_Set
* V_Syn4_Set  ->  V_Syn4_Set
* V_Syn_State  ->  V_Syn_State
* V_Threshold  ->  V_Threshold
* Vm_Display_In  ->  Vm_Display_In
* Vm_Ext  ->  Vm_Ext
* Vm_FB  ->  Vm_FB
* Vm_Int  ->  Vm_Int
* Vm_Out_DRV  ->  Vm_Out_DRV
* Vsel  ->  Vsel
* Vw  ->  Vw
* Vw_buff  ->  Vw_buff
* unconnected-(J3-Pad1)  ->  unconnected_J3_Pad1
* unconnected-(J4-Pad1)  ->  unconnected_J4_Pad1
* unconnected-(J5-Pad1)  ->  unconnected_J5_Pad1
* unconnected-(J6-Pad1)  ->  unconnected_J6_Pad1
* unconnected-(SW1-C-Pad3)  ->  unconnected_SW1_C_Pad3

* -----------------------------------------------------------------------------
* All fixed resistors from the KiCad netlist
* -----------------------------------------------------------------------------
R_R1 Net_U7_VOUT V_Boost 10    $ R1=10Ω, Net-(U7-VOUT) <-> V_Boost
R_R2 Vm_Out_DRV Vm_Ext 220    $ R2=220Ω, Vm_Out_DRV <-> Vm_Ext
R_R3 Vm_FB Vm_Out_DRV 10k    $ R3=10kΩ, Vm_FB <-> Vm_Out_DRV
R_R4 0 Vm_FB 100k    $ R4=100kΩ, GNDREF <-> Vm_FB
R_R5 VREF_1V024_RAW VREF_2V048 220k    $ R5=220kΩ, VREF_1V024_RAW <-> VREF_2V048
R_R6 0 VREF_1V024_RAW 220k    $ R6=220kΩ, GNDREF <-> VREF_1V024_RAW
R_R7 V_Threshold VREF_1V024 20k    $ R7=20kΩ, V_Threshold <-> VREF_1V024
R_R8 V_Threshold 0 100k    $ R8=100kΩ, V_Threshold <-> GNDREF
R_R9 VREF_1V024 V_Reset_Ref 100k    $ R9=100kΩ, VREF_1V024 <-> V_Reset_Ref
R_R10 0 V_Reset_Ref 56k    $ R10=56kΩ, GNDREF <-> V_Reset_Ref
R_R11 VDD V_Peak_Ref 100k    $ R11=100kΩ, VDD <-> V_Peak_Ref
R_R12 0 V_Peak_Ref 1Meg    $ R12=1MΩ, GNDREF <-> V_Peak_Ref
R_R13 V_Logic_Mid VDD 220k    $ R13=220kΩ, V_Logic_Mid <-> VDD
R_R14 0 V_Logic_Mid 220k    $ R14=220kΩ, GNDREF <-> V_Logic_Mid
R_R15 Vm_Display_In Vm_Int 100k    $ R15=100kΩ, Vm_Display_In <-> Vm_Int
R_R16 Net_U20_NO V_Peak_Drive 10k    $ R16=10kΩ, Net-(U20-NO) <-> V_Peak_Drive
R_R17 VDD T4 100k    $ R17=100kΩ, VDD <-> T4
R_R18 T4 T3 100k    $ R18=100kΩ, T4 <-> T3
R_R19 T3 T2 100k    $ R19=100kΩ, T3 <-> T2
R_R20 T2 T1 100k    $ R20=100kΩ, T2 <-> T1
R_R21 T1 0 100k    $ R21=100kΩ, T1 <-> GNDREF
R_R22 VDD S0 100k    $ R22=100kΩ, VDD <-> S0
R_R23 T1 S0 1Meg    $ R23=1MΩ, T1 <-> S0
R_R24 VDD S1 100k    $ R24=100kΩ, VDD <-> S1
R_R25 T1 S1 1Meg    $ R25=1MΩ, T1 <-> S1
R_R26 T2 S1 1Meg    $ R26=1MΩ, T2 <-> S1
R_R27 VDD S2 100k    $ R27=100kΩ, VDD <-> S2
R_R28 T2 S2 1Meg    $ R28=1MΩ, T2 <-> S2
R_R29 T3 S2 1Meg    $ R29=1MΩ, T3 <-> S2
R_R30 VDD S3 100k    $ R30=100kΩ, VDD <-> S3
R_R31 T3 S3 1Meg    $ R31=1MΩ, T3 <-> S3
R_R32 T4 S3 1Meg    $ R32=1MΩ, T4 <-> S3
R_R33 VDD S4 100k    $ R33=100kΩ, VDD <-> S4
R_R34 T4 S4 1Meg    $ R34=1MΩ, T4 <-> S4
R_R35 Net_R35_Pad1 Vm_Int 1k    $ R35=1kΩ, Net-(R35-Pad1) <-> Vm_Int
R_R36 V_Threshold N_AP_Gate 2.2Meg    $ R36=2.2MΩ, V_Threshold <-> /AP_Gate
R_R37 VDD N_AP_Gate 10k    $ R37=10kΩ, VDD <-> /AP_Gate
R_R38 VDD AP 100k    $ R38=100kΩ, VDD <-> AP
R_R39 0 N_Vkick 22k    $ R39=22kΩ, GNDREF <-> /Vkick
R_R40 Net_R40_Pad1 0 100    $ R40=100Ω, Net-(R40-Pad1) <-> GNDREF
R_R41 0 Net_U1A_VINBP 200k    $ R41=200kΩ, GNDREF <-> Net-(U1A-VINB+)
R_R42 Net_U1A_VINBP Vm_Int 100k    $ R42=100kΩ, Net-(U1A-VINB+) <-> Vm_Int
R_R43 Net_U1A_VINB V_Leak 100k    $ R43=100kΩ, Net-(U1A-VINB-) <-> V_Leak
R_R44 Net_U1A_VINB Net_U1A_VOUTB 200k    $ R44=200kΩ, Net-(U1A-VINB-) <-> Net-(U1A-VOUTB)
R_R45 Net_U1A_VOUTB Net_D6_A 330k    $ R45=330kΩ, Net-(U1A-VOUTB) <-> Net-(D6-A)
R_R46 Vm_Int N_Adapt_Current_Sink 10k    $ R46=10kΩ, Vm_Int <-> /Adapt_Current_Sink
R_R47 N_Adapt_Base Vw_buff 22k    $ R47=22kΩ, /Adapt_Base <-> Vw_buff
R_R48 N_Adapt_Base 0 100k    $ R48=100kΩ, /Adapt_Base <-> GNDREF
R_R49 N_Rising_AP 0 100k    $ R49=100kΩ, /Rising_AP <-> GNDREF
R_R50 0 Spike_Pulse 1Meg    $ R50=1MΩ, GNDREF <-> Spike_Pulse
R_R51 VDD Peak_Window 100k    $ R51=100kΩ, VDD <-> Peak_Window
R_R52 Net_U14_NO V_Peak_Drive 10k    $ R52=10kΩ, Net-(U14-NO) <-> V_Peak_Drive
R_R53 VDD Net_U6C_INC 22k    $ R53=22kΩ, VDD <-> Net-(U6C-INC-)
R_R54 N_Reset_Timer_Discharge Net_U6C_INC 100    $ R54=100Ω, /Reset_Timer_Discharge <-> Net-(U6C-INC-)
R_R55 VDD Reset_Window 100k    $ R55=100kΩ, VDD <-> Reset_Window
R_R56 Net_U6C_INCP VDD 270k    $ R56=270kΩ, Net-(U6C-INC+) <-> VDD
R_R57 Net_U6C_INCP Reset_Window 1Meg    $ R57=1MΩ, Net-(U6C-INC+) <-> Reset_Window
R_R58 0 Net_U6C_INCP 220k    $ R58=220kΩ, GNDREF <-> Net-(U6C-INC+)
R_R59 VDD N_Reset_Injection_Enable 100k    $ R59=100kΩ, VDD <-> /Reset_Injection_Enable
R_R60 N_Reset_Gated_Drive Vm_Int 10k    $ R60=10kΩ, /Reset_Gated_Drive <-> Vm_Int
R_R61 Net_Q7_D Net_D9_B 2k    $ R61=2kΩ, Net-(Q7-D) <-> Net-(D9-B-)
R_R62 Net_Q7_D Net_D9_G 2k    $ R62=2kΩ, Net-(Q7-D) <-> Net-(D9-G-)
R_R63 Net_Q8_Pad3 Net_D9_R 2k    $ R63=2kΩ, Net-(Q8-Pad3) <-> Net-(D9-R-)
R_R64 Net_Q8_Pad1 Vm_Int 10k    $ R64=10kΩ, Net-(Q8-Pad1) <-> Vm_Int
R_R65 Net_Q8_Pad1 0 100k    $ R65=100kΩ, Net-(Q8-Pad1) <-> GNDREF
R_R66 Net_U15_NO V_Syn_State 22k    $ R66=22kΩ, Net-(U15-NO) <-> V_Syn_State
R_R67 Net_U15_IN Net_D10_A 1k    $ R67=1kΩ, Net-(U15-IN) <-> Net-(D10-A)
R_R68 0 Net_D10_A 100k    $ R68=100kΩ, GNDREF <-> Net-(D10-A)
R_R69 Syn1_Spike Net_D10_A 22k    $ R69=22kΩ, Syn1_Spike <-> Net-(D10-A)
R_R70 Net_U16_NO V_Syn_State 22k    $ R70=22kΩ, Net-(U16-NO) <-> V_Syn_State
R_R71 Net_U16_IN Net_D12_A 1k    $ R71=1kΩ, Net-(U16-IN) <-> Net-(D12-A)
R_R72 0 Net_D12_A 100k    $ R72=100kΩ, GNDREF <-> Net-(D12-A)
R_R73 Syn2_Spike Net_D12_A 22k    $ R73=22kΩ, Syn2_Spike <-> Net-(D12-A)
R_R74 Net_U17_NO V_Syn_State 22k    $ R74=22kΩ, Net-(U17-NO) <-> V_Syn_State
R_R75 Net_U17_IN Net_D14_A 1k    $ R75=1kΩ, Net-(U17-IN) <-> Net-(D14-A)
R_R76 0 Net_D14_A 100k    $ R76=100kΩ, GNDREF <-> Net-(D14-A)
R_R77 Syn3_Spike Net_D14_A 22k    $ R77=22kΩ, Syn3_Spike <-> Net-(D14-A)
R_R78 Net_U18_NO V_Syn_State 22k    $ R78=22kΩ, Net-(U18-NO) <-> V_Syn_State
R_R79 Net_U18_IN Net_D16_A 1k    $ R79=1kΩ, Net-(U18-IN) <-> Net-(D16-A)
R_R80 0 Net_D16_A 100k    $ R80=100kΩ, GNDREF <-> Net-(D16-A)
R_R81 Syn4_Spike Net_D16_A 22k    $ R81=22kΩ, Syn4_Spike <-> Net-(D16-A)
R_R82 V_Syn_State Net_R82_Pad2 10k    $ R82=10kΩ, V_Syn_State <-> Net-(R82-Pad2)
R_R83 V_Syn_State Net_U2C_VINDP 1Meg    $ R83=1MΩ, V_Syn_State <-> Net-(U2C-VIND+)
R_R84 Vm_Int Net_U2C_VINDP 1Meg    $ R84=1MΩ, Vm_Int <-> Net-(U2C-VIND+)
R_R85 VREF_1V024 Net_U2C_VIND 1Meg    $ R85=1MΩ, VREF_1V024 <-> Net-(U2C-VIND-)
R_R86 Net_U2C_VIND N_V_Syn_Drive 1Meg    $ R86=1MΩ, Net-(U2C-VIND-) <-> /V_Syn_Drive
R_R87 N_V_Syn_Drive Vm_Int 47k    $ R87=47kΩ, /V_Syn_Drive <-> Vm_Int
R_R88 VDD Net_U19_OUT 100k    $ R88=100kΩ, VDD <-> Net-(U19-OUT)
R_R89 Net_U19_OUT Spike_Out 100    $ R89=100Ω, Net-(U19-OUT) <-> Spike_Out
R_R90 VREF_1V024 V_Stim_Cmd 1Meg    $ R90=1MΩ, VREF_1V024 <-> V_Stim_Cmd
R_R91 Stimulus_Ext V_Stim_Cmd 1k    $ R91=1kΩ, Stimulus_Ext <-> V_Stim_Cmd
R_R92 Vm_Int Net_U6B_INBP 100k    $ R92=100kΩ, Vm_Int <-> Net-(U6B-INB+)
R_R93 V_Stim_Cmd Net_U6B_INBP 200k    $ R93=200kΩ, V_Stim_Cmd <-> Net-(U6B-INB+)
R_R94 VREF_1V024 Net_U6B_INB 200k    $ R94=200kΩ, VREF_1V024 <-> Net-(U6B-INB-)
R_R95 V_Stim_Drive Net_U6B_INB 100k    $ R95=100kΩ, V_Stim_Drive <-> Net-(U6B-INB-)
R_R96 VDD V_Stim_Drive 100k    $ R96=100kΩ, VDD <-> V_Stim_Drive
R_R97 V_Stim_Drive Vm_Int 100k    $ R97=100kΩ, V_Stim_Drive <-> Vm_Int

* -----------------------------------------------------------------------------
* All potentiometers as two explicit end-to-wiper resistances
* fraction=0 means wiper at pin1, fraction=1 means wiper at pin3
* -----------------------------------------------------------------------------
* RV1=100kΩ, fraction=0.7000; pin1=GNDREF, pin2=/V_Leak_ref, pin3=V_Leak_Ref_Max
R_RV1_P1_W 0 N_V_Leak_ref 70000
R_RV1_W_P3 N_V_Leak_ref V_Leak_Ref_Max 30000
* RV2=50kΩ, fraction=0.5000; pin1=Net-(R35-Pad1), pin2=Vm_Int, pin3=V_Leak
R_RV2_P1_W Net_R35_Pad1 Vm_Int 25000
R_RV2_W_P3 Vm_Int V_Leak 25000
* RV3=100kΩ, fraction=0.8000; pin1=Vw, pin2=Vw, pin3=Net-(R40-Pad1)
* R_RV3_P1_W skipped because pin1 and pin2 are the same net
R_RV3_W_P3 Vw Net_R40_Pad1 20000
* RV4=100kΩ, fraction=0.3000; pin1=GNDREF, pin2=Vsel, pin3=VDD
R_RV4_P1_W 0 Vsel 30000
R_RV4_W_P3 Vsel VDD 70000
* RV5=100kΩ, fraction=0.5000; pin1=Net-(R82-Pad2), pin2=Net-(R82-Pad2), pin3=VREF_1V024
* R_RV5_P1_W skipped because pin1 and pin2 are the same net
R_RV5_W_P3 Net_R82_Pad2 VREF_1V024 50000
* RV6=1MΩ, fraction=1.0000; pin1=GNDREF, pin2=Net-(U3A-VINB+), pin3=VREF_2V048
R_RV6_P1_W 0 Net_U3A_VINBP 999999
R_RV6_W_P3 Net_U3A_VINBP VREF_2V048 1.00000000003
* RV7=1MΩ, fraction=1.0000; pin1=GNDREF, pin2=Net-(U3B-VINC+), pin3=VREF_2V048
R_RV7_P1_W 0 Net_U3B_VINCP 999999
R_RV7_W_P3 Net_U3B_VINCP VREF_2V048 1.00000000003
* RV8=1MΩ, fraction=1.0000; pin1=GNDREF, pin2=Net-(U3C-VIND+), pin3=VREF_2V048
R_RV8_P1_W 0 Net_U3C_VINDP 999999
R_RV8_W_P3 Net_U3C_VINDP VREF_2V048 1.00000000003
* RV9=1MΩ, fraction=1.0000; pin1=GNDREF, pin2=Net-(U3D-VINA+), pin3=VREF_2V048
R_RV9_P1_W 0 Net_U3D_VINAP 999999
R_RV9_W_P3 Net_U3D_VINAP VREF_2V048 1.00000000003

* -----------------------------------------------------------------------------
* All capacitors from the KiCad netlist
* -----------------------------------------------------------------------------
C_C1 P_BATT 0 10u    $ C1=10uF, +BATT <-> GNDREF
C_C2 VDD 0 10u    $ C2=10uF, VDD <-> GNDREF
C_C3 0 VDD 100n    $ C3=100nF, GNDREF <-> VDD
C_C4 0 VDD 100n    $ C4=100nF, GNDREF <-> VDD
C_C5 0 VDD 100n    $ C5=100nF, GNDREF <-> VDD
C_C6 0 VDD 100n    $ C6=100nF, GNDREF <-> VDD
C_C7 0 VDD 100n    $ C7=100nF, GNDREF <-> VDD
C_C8 0 VDD 100n    $ C8=100nF, GNDREF <-> VDD
C_C9 VDD 0 10u    $ C9=10uF, VDD <-> GNDREF
C_C10 0 Net_U7_VOUT 22u    $ C10=22uF, GNDREF <-> Net-(U7-VOUT)
C_C11 V_Boost 0 1u    $ C11=1uF, V_Boost <-> GNDREF
C_C12 V_Boost 0 100n    $ C12=100nF, V_Boost <-> GNDREF
C_C13 Vm_Ext 0 100p    $ C13=100pF, Vm_Ext <-> GNDREF
C_C14 V_Boost 0 100n    $ C14=100nF, V_Boost <-> GNDREF
C_C15 VREF_2V048 0 100n    $ C15=100nF, VREF_2V048 <-> GNDREF
C_C16 0 Vm_Display_In 22n    $ C16=22nF, GNDREF <-> Vm_Display_In
C_C17 VDD 0 100n    $ C17=100nF, VDD <-> GNDREF
C_C18 Net_U9_NO 0 470n    $ C18=470nF, Net-(U9-NO) <-> GNDREF
C_C19 VDD 0 100n    $ C19=100nF, VDD <-> GNDREF
C_C20 Net_U10_NO 0 1u    $ C20=1uF, Net-(U10-NO) <-> GNDREF
C_C21 VDD 0 100n    $ C21=100nF, VDD <-> GNDREF
C_C22 Net_U11_NO 0 2.2u    $ C22=2.2uF, Net-(U11-NO) <-> GNDREF
C_C23 VDD 0 100n    $ C23=100nF, VDD <-> GNDREF
C_C24 Net_U12_NO 0 4.7u    $ C24=4.7uF, Net-(U12-NO) <-> GNDREF
C_C25 VDD 0 100n    $ C25=100nF, VDD <-> GNDREF
C_C26 Net_U13_NO 0 10u    $ C26=10uF, Net-(U13-NO) <-> GNDREF
C_C27 VDD 0 100n    $ C27=100nF, VDD <-> GNDREF
C_C28 0 Vm_Int 100p    $ C28=100pF, GNDREF <-> Vm_Int
C_C29 N_Vkick N_Adapt_Kick_Drive 1u    $ C29=1uF, /Vkick <-> /Adapt_Kick_Drive
C_C30 0 Vw 10u    $ C30=10uF, GNDREF <-> Vw
C_C31 AP N_Rising_AP 10n    $ C31=10nF, AP <-> /Rising_AP
C_C32 VDD 0 100n    $ C32=100nF, VDD <-> GNDREF
C_C33 0 Net_U6C_INC 1u    $ C33=1uF, GNDREF <-> Net-(U6C-INC-)
C_C34 VDD 0 100n    $ C34=100nF, VDD <-> GNDREF
C_C35 VDD 0 100n    $ C35=100nF, VDD <-> GNDREF
C_C36 VDD 0 100n    $ C36=100nF, VDD <-> GNDREF
C_C37 VDD 0 100n    $ C37=100nF, VDD <-> GNDREF
C_C38 0 V_Syn_State 220n    $ C38=220nF, GNDREF <-> V_Syn_State
C_C39 V_Stim_Cmd 0 100p    $ C39=100pF, V_Stim_Cmd <-> GNDREF
C_C41 0 VDD 100n    $ C41=100nF, GNDREF <-> VDD

* -----------------------------------------------------------------------------
* All inductors from the KiCad netlist
* -----------------------------------------------------------------------------
L_L1 VDD Net_U7_SW 2.2u    $ L1=2.2uH, VDD <-> Net-(U7-SW)
R_U7_SW_LEAK Net_U7_SW 0 1G    $ convergence leakage on TPS610995 switching node

* -----------------------------------------------------------------------------
* Diodes, Schottky clamps, ESD approximations, and RGB LED
* -----------------------------------------------------------------------------
* Pin-orientation note: diode orientation is assigned by circuit function and KiCad net labels,
* because imported symbols do not use one uniform pin-number convention.
C_D1_ESD Vm_Ext 0 1p    $ D1 TPD1E05U06DPYT capacitance approximation
R_D1_LEAK Vm_Ext 0 1G    $ D1 leakage approximation
C_D18_ESD Spike_Out 0 1p    $ D18 TPD1E05U06DPYT capacitance approximation
R_D18_LEAK Spike_Out 0 1G    $ D18 leakage approximation
C_D19_ESD Stimulus_Ext 0 1p    $ D19 TPD1E05U06DPYT capacitance approximation
R_D19_LEAK Stimulus_Ext 0 1G    $ D19 leakage approximation
D_D2_VM_HIGH Vm_Int VDD BAT54_FALLBACK    $ D2 high clamp: Vm_Int -> VDD
D_D3_VM_LOW 0 Vm_Int BAT54_FALLBACK    $ D3 low clamp: GNDREF -> Vm_Int
D_D4_VKICK_LOW 0 N_Vkick D1N4148_FALLBACK    $ D4 clamps negative /Vkick
D_D5_VKICK_TO_VW N_Vkick Vw D1N4148_FALLBACK    $ D5 /Vkick -> Vw
D_D6_ADAPT_TO_VW Net_D6_A Vw RB521S30_FALLBACK    $ D6 Schottky adaptation injection
D_D7_VW_LOW 0 Vw D1N4148_FALLBACK    $ D7 clamps negative Vw
D_D8_RISING_TO_SPIKE N_Rising_AP Spike_Pulse RB521S30_FALLBACK    $ D8 positive differentiator diode
D_D20_SPIKE_LOW 0 Spike_Pulse RB521S30_FALLBACK    $ D20 negative Spike_Pulse clamp
D_D10_SYN1_HIGH Net_D10_A VDD BAT54_FALLBACK    $ D10 Syn1 high clamp
D_D11_SYN1_LOW 0 Net_D10_A BAT54_FALLBACK    $ D11 Syn1 low clamp
D_D12_SYN2_HIGH Net_D12_A VDD BAT54_FALLBACK    $ D12 Syn2 high clamp
D_D13_SYN2_LOW 0 Net_D12_A BAT54_FALLBACK    $ D13 Syn2 low clamp
D_D14_SYN3_HIGH Net_D14_A VDD BAT54_FALLBACK    $ D14 Syn3 high clamp
D_D15_SYN3_LOW 0 Net_D14_A BAT54_FALLBACK    $ D15 Syn3 low clamp
D_D16_SYN4_HIGH Net_D16_A VDD BAT54_FALLBACK    $ D16 Syn4 high clamp
D_D17_SYN4_LOW 0 Net_D16_A BAT54_FALLBACK    $ D17 Syn4 low clamp
D_D21_DISPLAY_HIGH Vm_Display_In VDD BAT54_FALLBACK    $ D21 display high clamp
D_D22_DISPLAY_LOW 0 Vm_Display_In BAT54_FALLBACK    $ D22 display low clamp
D_D9_R VDD Net_D9_R LED_RED_FALLBACK      $ D9 red LED, common anode VDD
D_D9_G VDD Net_D9_G LED_GREEN_FALLBACK    $ D9 green LED, common anode VDD
D_D9_B VDD Net_D9_B LED_BLUE_FALLBACK     $ D9 blue LED, common anode VDD

* -----------------------------------------------------------------------------
* Power sources and active IC behavioural models
* -----------------------------------------------------------------------------
* BT1/SW1: coin-cell source, optional internal resistance, and closed power switch.
V_BT1_RAW VBAT_RAW 0 DC 3       $ BT1 open-circuit coin-cell voltage
R_BT1_INTERNAL VBAT_RAW P_BATT 50 $ BT1 internal/source resistance
R_SW1_ON P_BATT VDD 0.2 $ SW1 pin2(+BATT) -> pin1(VDD), ON position

* U7 TPS610995 boost converter approximation.
* The real switching converter, L1 and output capacitors are reduced to an ideal boosted rail.
* L1, C10, C11, C12 and C14 are still present as passive netlist components above.
B_U7_BOOST Net_U7_VOUT 0 V={ 3.3 }

* U21 REF3020AIDBZR 2.048 V precision reference.
* Output is clamped by VDD so brownout tests remain physically bounded.
B_U21_REF3020 VREF_2V048 0 V={min(2.048,max(0,V(VDD)))}

* U22 TLV9001 buffer: VREF_1V024_RAW -> VREF_1V024.
E_U22_FOLLOW VREF_1V024 0 VREF_1V024_RAW 0 1

* U1 MCP6004 analogue core.
* U1A leak buffer: /V_Leak_ref -> V_Leak.
E_U1A_FOLLOW V_Leak 0 N_V_Leak_ref 0 1
* U1B adaptation shaping amplifier with R41/R42/R43/R44/R45 feedback network.
* Closed-loop fallback: Vout = 3*V(Net-(U1A-VINB+)) - 2*V(V_Leak), from R43=100k/R44=200k.
B_U1B_CL U1B_RAW 0 V={min(max((3*V(Net_U1A_VINBP)-2*V(V_Leak)),0),V(VDD))}    $ U1B closed-loop adaptation shaper; avoids high-gain feedback convergence at t=0
R_U1B_OUT U1B_RAW Net_U1A_VOUTB 100
* U1C AP follower driving /Adapt_Kick_Drive through C29 into /Vkick.
E_U1C_FOLLOW N_Adapt_Kick_Drive 0 AP 0 1
* U1D adaptation-state buffer: Vw -> Vw_buff.
E_U1D_FOLLOW Vw_buff 0 Vw 0 1

* U2 MCP6004 reference, reset, peak, and centred synaptic-drive amplifiers.
* U2A: VREF_2V048 -> V_Leak_Ref_Max. This is the new global top reference for RV1.
E_U2A_FOLLOW V_Leak_Ref_Max 0 VREF_2V048 0 1
* U2B: V_Reset_Ref -> /Reset_Injection_Drive.
E_U2B_FOLLOW N_Reset_Injection_Drive 0 V_Reset_Ref 0 1
* U2C: V_Peak_Ref -> V_Peak_Drive.
E_U2C_FOLLOW V_Peak_Drive 0 V_Peak_Ref 0 1
* U2D: centred synapse drive using R83/R84/R85/R86 feedback.
* Closed-loop fallback with equal 1M resistors: /V_Syn_Drive = V_Syn_State + Vm_Int - VREF_1V024.
* Therefore the synapse injects zero current through R87 when V_Syn_State = VREF_1V024.
B_U2D_CL U2D_RAW 0 V={min(max((V(V_Syn_State)+V(Vm_Int)-V(VREF_1V024)),0),V(VDD))}    $ U2D closed-loop centred synapse driver; zero effect at 1.024 V state
R_U2D_OUT U2D_RAW N_V_Syn_Drive 100

* U3 MCP6004 four synaptic set-voltage buffers from RV6..RV9.
E_U3A_SYN1_FOLLOW V_Syn1_Set 0 Net_U3A_VINBP 0 1
E_U3B_SYN2_FOLLOW V_Syn2_Set 0 Net_U3B_VINCP 0 1
E_U3C_SYN3_FOLLOW V_Syn3_Set 0 Net_U3C_VINDP 0 1
E_U3D_SYN4_FOLLOW V_Syn4_Set 0 Net_U3D_VINAP 0 1

* U8 TLV9001 Vm_Ext output driver powered from V_Boost.
* R3/R4 set the non-inverting gain; R2/C13/D1 form the protected external output.
* Closed-loop fallback: Vm_Out_DRV = (1 + R3/R4)*Vm_Display_In = 1.1*Vm_Display_In.
B_U8_CL U8_RAW 0 V={min(max((1.1*V(Vm_Display_In)),0),V(V_Boost))}    $ U8 closed-loop Vm_Ext driver; removes high-gain loop at Vm_Out_DRV
R_U8_OUT U8_RAW Vm_Out_DRV 25

* U4/U5 TLV7044 comparators implement RV4/Vsel capacitor-bank one-hot selection.
* S0 high for Vsel<T1; S1 high for T1<Vsel<T2; S2 high for T2<Vsel<T3;
* S3 high for T3<Vsel<T4; S4 high for Vsel>T4. Tied outputs are open-drain ANDs.
B_U4A_S0_OD_SINK S0 0 I={ V(S0)*(1e-12 + (0.2-1e-12)*0.5*(1+tanh(200*(V(Vsel)-V(T1))))) }    $ U4A_S0: smooth open-drain sink, low when Vsel > T1
C_U4A_S0_OD_NUM S0 0 0.2p    $ tiny numerical output capacitance for U4A_S0
B_U4B_S1_LOW_OD_SINK S1 0 I={ V(S1)*(1e-12 + (0.2-1e-12)*0.5*(1+tanh(200*(V(T1)-V(Vsel))))) }    $ U4B_S1_LOW: smooth open-drain sink, low when T1 > Vsel
C_U4B_S1_LOW_OD_NUM S1 0 0.2p    $ tiny numerical output capacitance for U4B_S1_LOW
B_U4C_S1_HIGH_OD_SINK S1 0 I={ V(S1)*(1e-12 + (0.2-1e-12)*0.5*(1+tanh(200*(V(Vsel)-V(T2))))) }    $ U4C_S1_HIGH: smooth open-drain sink, low when Vsel > T2
C_U4C_S1_HIGH_OD_NUM S1 0 0.2p    $ tiny numerical output capacitance for U4C_S1_HIGH
B_U4D_S2_LOW_OD_SINK S2 0 I={ V(S2)*(1e-12 + (0.2-1e-12)*0.5*(1+tanh(200*(V(T2)-V(Vsel))))) }    $ U4D_S2_LOW: smooth open-drain sink, low when T2 > Vsel
C_U4D_S2_LOW_OD_NUM S2 0 0.2p    $ tiny numerical output capacitance for U4D_S2_LOW
B_U5D_S2_HIGH_OD_SINK S2 0 I={ V(S2)*(1e-12 + (0.2-1e-12)*0.5*(1+tanh(200*(V(Vsel)-V(T3))))) }    $ U5D_S2_HIGH: smooth open-drain sink, low when Vsel > T3
C_U5D_S2_HIGH_OD_NUM S2 0 0.2p    $ tiny numerical output capacitance for U5D_S2_HIGH
B_U5B_S3_LOW_OD_SINK S3 0 I={ V(S3)*(1e-12 + (0.2-1e-12)*0.5*(1+tanh(200*(V(T3)-V(Vsel))))) }    $ U5B_S3_LOW: smooth open-drain sink, low when T3 > Vsel
C_U5B_S3_LOW_OD_NUM S3 0 0.2p    $ tiny numerical output capacitance for U5B_S3_LOW
B_U5C_S3_HIGH_OD_SINK S3 0 I={ V(S3)*(1e-12 + (0.2-1e-12)*0.5*(1+tanh(200*(V(Vsel)-V(T4))))) }    $ U5C_S3_HIGH: smooth open-drain sink, low when Vsel > T4
C_U5C_S3_HIGH_OD_NUM S3 0 0.2p    $ tiny numerical output capacitance for U5C_S3_HIGH
B_U5A_S4_OD_SINK S4 0 I={ V(S4)*(1e-12 + (0.2-1e-12)*0.5*(1+tanh(200*(V(T4)-V(Vsel))))) }    $ U5A_S4: smooth open-drain sink, low when T4 > Vsel
C_U5A_S4_OD_NUM S4 0 0.2p    $ tiny numerical output capacitance for U5A_S4

* U6 TLV7044 comparators.
* U6A Peak_Window: high when Spike_Pulse > V_Threshold.
B_U6A_PEAK_OD_SINK Peak_Window 0 I={ V(Peak_Window)*(1e-12 + (0.2-1e-12)*0.5*(1+tanh(200*(V(V_Threshold)-V(Spike_Pulse))))) }    $ U6A_PEAK: smooth open-drain sink, low when V_Threshold > Spike_Pulse
C_U6A_PEAK_OD_NUM Peak_Window 0 0.2p    $ tiny numerical output capacitance for U6A_PEAK
* U6B external stimulus drive: high when the R92/R93 summing node exceeds the R94/R95 feedback node.
B_U6B_STIM_OD_SINK V_Stim_Drive 0 I={ V(V_Stim_Drive)*(1e-12 + (0.2-1e-12)*0.5*(1+tanh(200*(V(Net_U6B_INB)-V(Net_U6B_INBP))))) }    $ U6B_STIM: smooth open-drain sink, low when Net-(U6B-INB-) > Net-(U6B-INB+)
C_U6B_STIM_OD_NUM V_Stim_Drive 0 0.2p    $ tiny numerical output capacitance for U6B_STIM
* U6C Reset_Window: high while reset reference node exceeds the reset timer node.
B_U6C_RESET_OD_SINK Reset_Window 0 I={ V(Reset_Window)*(1e-12 + (0.2-1e-12)*0.5*(1+tanh(200*(V(Net_U6C_INC)-V(Net_U6C_INCP))))) }    $ U6C_RESET: smooth open-drain sink, low when Net-(U6C-INC-) > Net-(U6C-INC+)
C_U6C_RESET_OD_NUM Reset_Window 0 0.2p    $ tiny numerical output capacitance for U6C_RESET
* U6D /AP_Gate: high below threshold, released low when Vm_Int exceeds V_Threshold.
B_U6D_AP_GATE_OD_SINK N_AP_Gate 0 I={ V(N_AP_Gate)*(1e-12 + (0.2-1e-12)*0.5*(1+tanh(200*(V(Vm_Int)-V(V_Threshold))))) }    $ U6D_AP_GATE: smooth open-drain sink, low when Vm_Int > V_Threshold
C_U6D_AP_GATE_OD_NUM N_AP_Gate 0 0.2p    $ tiny numerical output capacitance for U6D_AP_GATE

* U19 TLV7031 spike-output comparator: Peak_Window -> Spike_Out driver.
* R88 is the output pull-up and R89 is the 100 ohm series jack resistor.
B_U19_SPIKE_OUT_OD_SINK Net_U19_OUT 0 I={ V(Net_U19_OUT)*(1e-12 + (0.2-1e-12)*0.5*(1+tanh(200*(V(V_Logic_Mid)-V(Peak_Window))))) }    $ U19_SPIKE_OUT: smooth open-drain sink, low when V_Logic_Mid > Peak_Window
C_U19_SPIKE_OUT_OD_NUM Net_U19_OUT 0 0.2p    $ tiny numerical output capacitance for U19_SPIKE_OUT

* -----------------------------------------------------------------------------
* TS5A3166 analogue switches U9..U20
* KiCad pin mapping: pin1=NO, pin2=COM, pin3=GND, pin4=IN, pin5=VDD.
* -----------------------------------------------------------------------------
S_U9 Vm_Int Net_U9_NO S0 0 SW_TS5A3166    $ U9: COM=Vm_Int, NO=Net-(U9-NO), IN=S0
S_U10 Vm_Int Net_U10_NO S1 0 SW_TS5A3166    $ U10: COM=Vm_Int, NO=Net-(U10-NO), IN=S1
S_U11 Vm_Int Net_U11_NO S2 0 SW_TS5A3166    $ U11: COM=Vm_Int, NO=Net-(U11-NO), IN=S2
S_U12 Vm_Int Net_U12_NO S3 0 SW_TS5A3166    $ U12: COM=Vm_Int, NO=Net-(U12-NO), IN=S3
S_U13 Vm_Int Net_U13_NO S4 0 SW_TS5A3166    $ U13: COM=Vm_Int, NO=Net-(U13-NO), IN=S4
S_U14 Vm_Int Net_U14_NO Peak_Window 0 SW_TS5A3166    $ U14: COM=Vm_Int, NO=Net-(U14-NO), IN=Peak_Window
S_U15 V_Syn1_Set Net_U15_NO Net_U15_IN 0 SW_TS5A3166    $ U15: COM=V_Syn1_Set, NO=Net-(U15-NO), IN=Net-(U15-IN)
S_U16 V_Syn2_Set Net_U16_NO Net_U16_IN 0 SW_TS5A3166    $ U16: COM=V_Syn2_Set, NO=Net-(U16-NO), IN=Net-(U16-IN)
S_U17 V_Syn3_Set Net_U17_NO Net_U17_IN 0 SW_TS5A3166    $ U17: COM=V_Syn3_Set, NO=Net-(U17-NO), IN=Net-(U17-IN)
S_U18 V_Syn4_Set Net_U18_NO Net_U18_IN 0 SW_TS5A3166    $ U18: COM=V_Syn4_Set, NO=Net-(U18-NO), IN=Net-(U18-IN)
S_U19 0 Net_U19_OUT V_Logic_Mid 0 SW_TS5A3166    $ U19: COM=GNDREF, NO=Net-(U19-OUT), IN=V_Logic_Mid
S_U20 Vm_Display_In Net_U20_NO Peak_Window 0 SW_TS5A3166    $ U20: COM=Vm_Display_In, NO=Net-(U20-NO), IN=Peak_Window

* -----------------------------------------------------------------------------
* Discrete transistors
* BSS138 imported footprint mapping used here: pin1=gate, pin2=source, pin3=drain.
* MMBT3904 imported footprint mapping used here: pin1=base, pin2=emitter, pin3=collector.
* -----------------------------------------------------------------------------
M_Q1 AP N_AP_Gate 0 0 BSS138_FALLBACK    $ Q1: D=AP, G=/AP_Gate, S=GNDREF
Q_Q2 N_Adapt_Current_Sink N_Adapt_Base 0 MMBT3904_FALLBACK    $ Q2: C=/Adapt_Current_Sink, B=/Adapt_Base, E=GNDREF
M_Q3 N_Reset_Timer_Discharge AP 0 0 BSS138_FALLBACK    $ Q3: D=/Reset_Timer_Discharge, G=AP, S=GNDREF
M_Q4 N_Reset_Injection_Enable Peak_Window 0 0 BSS138_FALLBACK    $ Q4: D=/Reset_Injection_Enable, G=Peak_Window, S=GNDREF
M_Q5 N_Reset_Switch_Mid N_Reset_Injection_Enable N_Reset_Injection_Drive N_Reset_Injection_Drive BSS138_FALLBACK    $ Q5: D=/Reset_Switch_Mid, G=/Reset_Injection_Enable, S=/Reset_Injection_Drive
M_Q6 N_Reset_Gated_Drive Reset_Window N_Reset_Switch_Mid N_Reset_Switch_Mid BSS138_FALLBACK    $ Q6: D=/Reset_Gated_Drive, G=Reset_Window, S=/Reset_Switch_Mid
M_Q7 Net_Q7_D Reset_Window 0 0 BSS138_FALLBACK    $ Q7: D=Net-(Q7-D), G=Reset_Window, S=GNDREF
Q_Q8 Net_Q8_Pad3 Net_Q8_Pad1 0 MMBT3904_FALLBACK    $ Q8: C=Net-(Q8-Pad3), B=Net-(Q8-Pad1), E=GNDREF

* -----------------------------------------------------------------------------
* Optional external jack stimulus sources
* -----------------------------------------------------------------------------
* J1 ring Stimulus_Ext has no external source; schematic bias network defines it.
V_SYN1_SPIKE Syn1_Spike 0 PULSE(0 3.0 150m 1u 1u 5m 100m)
V_SYN2_SPIKE Syn2_Spike 0 PULSE(0 3.0 150m 1u 1u 5m 100m)
V_SYN3_SPIKE Syn3_Spike 0 PULSE(0 3.0 150m 1u 1u 5m 100m)
V_SYN4_SPIKE Syn4_Spike 0 PULSE(0 3.0 150m 1u 1u 5m 100m)

* -----------------------------------------------------------------------------
* Very weak leakage on every non-ground net for numerical convergence
* -----------------------------------------------------------------------------
R_LEAK_P_BATT P_BATT 0 10G
R_LEAK_N_AP_Gate N_AP_Gate 0 10G
R_LEAK_N_Adapt_Base N_Adapt_Base 0 10G
R_LEAK_N_Adapt_Current_Sink N_Adapt_Current_Sink 0 10G
R_LEAK_N_Adapt_Kick_Drive N_Adapt_Kick_Drive 0 10G
R_LEAK_N_Reset_Gated_Drive N_Reset_Gated_Drive 0 10G
R_LEAK_N_Reset_Injection_Drive N_Reset_Injection_Drive 0 10G
R_LEAK_N_Reset_Injection_Enable N_Reset_Injection_Enable 0 10G
R_LEAK_N_Reset_Switch_Mid N_Reset_Switch_Mid 0 10G
R_LEAK_N_Reset_Timer_Discharge N_Reset_Timer_Discharge 0 10G
R_LEAK_N_Rising_AP N_Rising_AP 0 10G
R_LEAK_N_V_Leak_ref N_V_Leak_ref 0 10G
R_LEAK_N_V_Syn_Drive N_V_Syn_Drive 0 10G
R_LEAK_N_Vkick N_Vkick 0 10G
R_LEAK_AP AP 0 10G
R_LEAK_Net_D10_A Net_D10_A 0 10G
R_LEAK_Net_D12_A Net_D12_A 0 10G
R_LEAK_Net_D14_A Net_D14_A 0 10G
R_LEAK_Net_D16_A Net_D16_A 0 10G
R_LEAK_Net_D6_A Net_D6_A 0 10G
R_LEAK_Net_D9_B Net_D9_B 0 10G
R_LEAK_Net_D9_G Net_D9_G 0 10G
R_LEAK_Net_D9_R Net_D9_R 0 10G
R_LEAK_Net_Q7_D Net_Q7_D 0 10G
R_LEAK_Net_Q8_Pad1 Net_Q8_Pad1 0 10G
R_LEAK_Net_Q8_Pad3 Net_Q8_Pad3 0 10G
R_LEAK_Net_R35_Pad1 Net_R35_Pad1 0 10G
R_LEAK_Net_R40_Pad1 Net_R40_Pad1 0 10G
R_LEAK_Net_R82_Pad2 Net_R82_Pad2 0 10G
R_LEAK_Net_U10_NO Net_U10_NO 0 10G
R_LEAK_Net_U11_NO Net_U11_NO 0 10G
R_LEAK_Net_U12_NO Net_U12_NO 0 10G
R_LEAK_Net_U13_NO Net_U13_NO 0 10G
R_LEAK_Net_U14_NO Net_U14_NO 0 10G
R_LEAK_Net_U15_IN Net_U15_IN 0 10G
R_LEAK_Net_U15_NO Net_U15_NO 0 10G
R_LEAK_Net_U16_IN Net_U16_IN 0 10G
R_LEAK_Net_U16_NO Net_U16_NO 0 10G
R_LEAK_Net_U17_IN Net_U17_IN 0 10G
R_LEAK_Net_U17_NO Net_U17_NO 0 10G
R_LEAK_Net_U18_IN Net_U18_IN 0 10G
R_LEAK_Net_U18_NO Net_U18_NO 0 10G
R_LEAK_Net_U19_OUT Net_U19_OUT 0 10G
R_LEAK_Net_U1A_VINBP Net_U1A_VINBP 0 10G
R_LEAK_Net_U1A_VINB Net_U1A_VINB 0 10G
R_LEAK_Net_U1A_VOUTB Net_U1A_VOUTB 0 10G
R_LEAK_Net_U20_NO Net_U20_NO 0 10G
R_LEAK_Net_U2C_VINDP Net_U2C_VINDP 0 10G
R_LEAK_Net_U2C_VIND Net_U2C_VIND 0 10G
R_LEAK_Net_U3A_VINBP Net_U3A_VINBP 0 10G
R_LEAK_Net_U3B_VINCP Net_U3B_VINCP 0 10G
R_LEAK_Net_U3C_VINDP Net_U3C_VINDP 0 10G
R_LEAK_Net_U3D_VINAP Net_U3D_VINAP 0 10G
R_LEAK_Net_U6B_INBP Net_U6B_INBP 0 10G
R_LEAK_Net_U6B_INB Net_U6B_INB 0 10G
R_LEAK_Net_U6C_INCP Net_U6C_INCP 0 10G
R_LEAK_Net_U6C_INC Net_U6C_INC 0 10G
R_LEAK_Net_U7_SW Net_U7_SW 0 10G
R_LEAK_Net_U7_VOUT Net_U7_VOUT 0 10G
R_LEAK_Net_U9_NO Net_U9_NO 0 10G
R_LEAK_Peak_Window Peak_Window 0 10G
R_LEAK_Reset_Window Reset_Window 0 10G
R_LEAK_S0 S0 0 10G
R_LEAK_S1 S1 0 10G
R_LEAK_S2 S2 0 10G
R_LEAK_S3 S3 0 10G
R_LEAK_S4 S4 0 10G
R_LEAK_Spike_Out Spike_Out 0 10G
R_LEAK_Spike_Pulse Spike_Pulse 0 10G
R_LEAK_Stimulus_Ext Stimulus_Ext 0 10G
R_LEAK_Syn1_Spike Syn1_Spike 0 10G
R_LEAK_Syn2_Spike Syn2_Spike 0 10G
R_LEAK_Syn3_Spike Syn3_Spike 0 10G
R_LEAK_Syn4_Spike Syn4_Spike 0 10G
R_LEAK_T1 T1 0 10G
R_LEAK_T2 T2 0 10G
R_LEAK_T3 T3 0 10G
R_LEAK_T4 T4 0 10G
R_LEAK_VDD VDD 0 10G
R_LEAK_VREF_1V024 VREF_1V024 0 10G
R_LEAK_VREF_1V024_RAW VREF_1V024_RAW 0 10G
R_LEAK_VREF_2V048 VREF_2V048 0 10G
R_LEAK_V_Boost V_Boost 0 10G
R_LEAK_V_Leak V_Leak 0 10G
R_LEAK_V_Leak_Ref_Max V_Leak_Ref_Max 0 10G
R_LEAK_V_Logic_Mid V_Logic_Mid 0 10G
R_LEAK_V_Peak_Drive V_Peak_Drive 0 10G
R_LEAK_V_Peak_Ref V_Peak_Ref 0 10G
R_LEAK_V_Reset_Ref V_Reset_Ref 0 10G
R_LEAK_V_Stim_Cmd V_Stim_Cmd 0 10G
R_LEAK_V_Stim_Drive V_Stim_Drive 0 10G
R_LEAK_V_Syn1_Set V_Syn1_Set 0 10G
R_LEAK_V_Syn2_Set V_Syn2_Set 0 10G
R_LEAK_V_Syn3_Set V_Syn3_Set 0 10G
R_LEAK_V_Syn4_Set V_Syn4_Set 0 10G
R_LEAK_V_Syn_State V_Syn_State 0 10G
R_LEAK_V_Threshold V_Threshold 0 10G
R_LEAK_Vm_Display_In Vm_Display_In 0 10G
R_LEAK_Vm_Ext Vm_Ext 0 10G
R_LEAK_Vm_FB Vm_FB 0 10G
R_LEAK_Vm_Int Vm_Int 0 10G
R_LEAK_Vm_Out_DRV Vm_Out_DRV 0 10G
R_LEAK_Vsel Vsel 0 10G
R_LEAK_Vw Vw 0 10G
R_LEAK_Vw_buff Vw_buff 0 10G
R_LEAK_unconnected_J3_Pad1 unconnected_J3_Pad1 0 10G
R_LEAK_unconnected_J4_Pad1 unconnected_J4_Pad1 0 10G
R_LEAK_unconnected_J5_Pad1 unconnected_J5_Pad1 0 10G
R_LEAK_unconnected_J6_Pad1 unconnected_J6_Pad1 0 10G
R_LEAK_unconnected_SW1_C_Pad3 unconnected_SW1_C_Pad3 0 10G

* -----------------------------------------------------------------------------
* Initial conditions
* -----------------------------------------------------------------------------
* Operating startup: begin close to the expected biased analogue operating point.
.ic V(P_BATT)=3 V(VDD)=3 V(V_Boost)=3.3 V(VREF_2V048)=2.048 V(VREF_1V024_RAW)=1.024 V(VREF_1V024)=1.024 V(Vm_Int)=0.60 V(Vm_Display_In)=0.60 V(V_Syn_State)=1.024 V(V_Leak)=0.6 V(AP)=0 V(Peak_Window)=0 V(Reset_Window)=0

* -----------------------------------------------------------------------------
* Analysis
* -----------------------------------------------------------------------------
.tran 10u 1.5 0 10u uic
.save V(VDD) V(V_Boost) V(VREF_2V048) V(VREF_1V024) V(V_Leak_Ref_Max) V(N_V_Leak_ref) V(V_Leak) V(Vm_Int) V(Vm_Display_In) V(Vm_Ext) V(V_Threshold) V(N_AP_Gate) V(AP) V(N_Rising_AP) V(Spike_Pulse) V(Peak_Window) V(Reset_Window) V(Spike_Out) V(V_Syn_State) V(N_V_Syn_Drive) V(V_Stim_Cmd) V(V_Stim_Drive) V(Vw) V(Vw_buff)
.control
run
wrdata C:/Users/mjyzi/Documents/GitHub/LIFeling/SPICE/LIFeling_pyspice_output/LIFeling_updated_14_synapse_repeating_simultaneous_high_stress_rv0p70_0p50_0p80_0p30_vb3_t1p5_syn1234_4b4a4192.raw.csv v(VDD) v(V_Boost) v(VREF_2V048) v(VREF_1V024) v(V_Leak_Ref_Max) v(N_V_Leak_ref) v(V_Leak) v(Vm_Int) v(Vm_Display_In) v(Vm_Ext) v(V_Threshold) v(N_AP_Gate) v(AP) v(N_Rising_AP) v(Spike_Pulse) v(Peak_Window) v(Reset_Window) v(Spike_Out) v(V_Syn_State) v(N_V_Syn_Drive) v(V_Stim_Cmd) v(V_Stim_Drive) v(Vw) v(Vw_buff)
quit
.endc
.end
