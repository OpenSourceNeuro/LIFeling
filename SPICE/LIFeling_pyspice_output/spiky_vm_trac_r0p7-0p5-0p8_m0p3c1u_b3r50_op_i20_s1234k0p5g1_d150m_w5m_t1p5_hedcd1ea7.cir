* Spiky_Lui2 Vm simulation: stage=threshold_reset_adapt
* Generated by Spice.py
* KiCad GNDREF is mapped to ngspice ground node 0.
.option method=gear reltol=1e-4 abstol=1e-12 vntol=1e-6 chgtol=1e-14
.option itl1=500 itl4=500
.temp 25

* ---- Fallback models: replace with vendor models for final analysis ----
.model D1N4148_FALLBACK D(Is=2.52n Rs=0.568 N=1.752 Cjo=2p M=0.4 Eg=1.11 Tt=4n)
.model RB521S30_FALLBACK D(Is=5u Rs=1 N=1.05 Cjo=10p Eg=0.69 Bv=30 Ibv=10u)
.model BAT54_FALLBACK D(Is=2u Rs=1 N=1.05 Cjo=10p Eg=0.69 Bv=30 Ibv=10u)
.model MMBT3904_FALLBACK NPN(Is=6.7f Bf=250 Vaf=100 Ikf=0.1 Xtb=1.5 Br=6 Cjc=4p Cje=8p Tf=300p Tr=50n)
.model BSS138_FALLBACK NMOS(Level=1 Vto=1.2 Kp=2m Lambda=0.02 Rd=2 Rs=2)
.model SW_OC SW(Ron=10 Roff=1e12 Vt=0 Vh=1m)
.model SW_TS5A3166 SW(Ron=0.9 Roff=1e12 Vt=1.5 Vh=0.05)

* ---- Supply and reference dividers ----
* ---- Non-ideal coin-cell supply model ----
VBAT VBAT_RAW 0 DC 3
RBAT VBAT_RAW VDD 50
* Local VDD decoupling after the battery/internal-resistance node.
RCDEC_LOCAL_ESR VDD CDEC_LOCAL_esr_node 0.2
CCDEC_LOCAL CDEC_LOCAL_esr_node 0 1e-07 IC=3
RCDEC_BULK_ESR VDD CDEC_BULK_esr_node 0.2
CCDEC_BULK CDEC_BULK_esr_node 0 1e-05 IC=3
RCDEC_RESERVOIR_ESR VDD CDEC_RESERVOIR_esr_node 0.2
CCDEC_RESERVOIR CDEC_RESERVOIR_esr_node 0 4.7e-05 IC=3

* Raw divider and global V_Leak_Ref_Max buffer.
* KiCad 2026-06-10: R4/R5 create V_Leak_Ref_Max_Raw; U2A buffers it to V_Leak_Ref_Max.
* V_Leak_Ref_Max then feeds every downstream use: RV1 pin3 and RV6..RV9 pin3.
R4 VDD V_Leak_Ref_Max_Raw 49900
R5 V_Leak_Ref_Max_Raw 0 100000
EU2A_LEAK_REF_MAX V_Leak_Ref_Max 0 V_Leak_Ref_Max_Raw 0 1

* RV1=50k: pin1=GNDREF, pin2=/V_Leak_ref, pin3=buffered V_Leak_Ref_Max; requested fraction=0.700, effective fraction=0.700
RV1_LOW V_Leak_ref 0 35000
RV1_HIGH V_Leak_Ref_Max V_Leak_ref 15000
EU1A V_Leak 0 V_Leak_ref 0 1

* Reset injection reference: R10=69.8k VDD->V_Reset_Ref, R11=10k V_Reset_Ref->GNDREF
R10 VDD V_Reset_Ref 69800
R11 V_Reset_Ref 0 10000
EU2B Reset_Injection_Drive 0 V_Reset_Ref 0 1

* Peak injection reference: R8=10k VDD->V_Peak_Ref, R9=100k V_Peak_Ref->GNDREF.
* U2C buffers V_Peak_Ref; U14/R49 later inject it into Vm_Int during Peak_Window.
R8 VDD V_Peak_Ref 10000
R9 V_Peak_Ref 0 100000
EU2C_PEAK V_Peak_Drive 0 V_Peak_Ref 0 1

* ---- Passive membrane core ----
* RV2 ground truth: pin1=Net-(R32-Pad1), pin2=Vm_Int, pin3=V_Leak, R32=1k pin1->Vm_Int.
* RV2 requested fraction=0.500, effective fraction=0.500
RV2_LOWER RV2_pin1 Vm_Int 25000
R32 RV2_pin1 Vm_Int 1000
RV2_UPPER V_Leak Vm_Int 25000
* Membrane capacitance selected by RV4: nominal=1u, actual=1e-06
CMEM_SELECTED Vm_Int 0 1e-06 IC=0.385
C26 Vm_Int 0 1e-10
* Vm_Int Schottky clamps from schematic: D2 to VDD and D3 to GNDREF.
DD2_VM_HIGH Vm_Int VDD BAT54_FALLBACK
DD3_VM_LOW 0 Vm_Int BAT54_FALLBACK

* ---- External stimulus path: U19B closed-loop equivalent ----
* No external stimulus source requested; jack node is biased weakly only for SPICE convergence.
RSTIM_EXT_BIAS Stimulus_Ext 0 1G
R83 Stimulus_Ext V_Stim_Cmd 1000
C37 V_Stim_Cmd 0 1e-10
R84 Vm_Int V_Stim_plus 100000
R85 V_Stim_Cmd V_Stim_plus 200000
R86 V_Leak V_Stim_minus 200000
R87 V_Stim_Drive V_Stim_minus 100000
BU19B_STIM_CL U19B_STIM_CL_raw 0 V={ min(max((1.5*V(V_Stim_plus)-0.5*V(V_Leak)),0),V(VDD)) }
RU19B_STIM_CL_OUT U19B_STIM_CL_raw V_Stim_Drive 100
R88 V_Stim_Drive Vm_Int 47000
CD19_ESD Stimulus_Ext 0 1e-12
RD19_LEAK Stimulus_Ext 0 1G

* ---- Vm_Ext display-spike synthesis and live-output driver ----
* New hardware: Vm_Int no longer drives U8 IN+ directly.
* R90 lets Vm_Display_In follow the internal membrane node without strongly loading Vm_Int.
R90 Vm_Display_In Vm_Int 100000
C38 Vm_Display_In 0 2.2e-08 IC=0.385
* Display-node BAT54WS clamps: D21 high clamp to VDD, D22 low clamp to GNDREF.
DD21_DISPLAY_HIGH Vm_Display_In VDD BAT54_FALLBACK
DD22_DISPLAY_LOW 0 Vm_Display_In BAT54_FALLBACK
* U20 display-spike switch: Peak_Window controls a short charge from buffered V_Peak_Drive.
* Peak_Window is used only as the switch control; V_Peak_Drive supplies the display-spike energy.
R91 V_Peak_Drive Display_Spike_NO 10000
SU20_DISPLAY_SPIKE Vm_Display_In Display_Spike_NO Peak_Window 0 SW_TS5A3166

* U8 TLV9001 live-output buffer, closed-loop equivalent.
* Real U8 V+ is V_Boost; behavioural model powers it from VDD because boost is out of scope.
R2 Vm_FB Vm_DRV 10000
R3 0 Vm_FB 100000
BU8_VM_EXT_CL U8_VM_EXT_CL_raw 0 V={ min(max((1.1*V(Vm_Display_In)),0),V(VDD)) }
RU8_VM_EXT_CL_OUT U8_VM_EXT_CL_raw Vm_DRV 25
R1 Vm_DRV Vm_Ext 220
C14 Vm_Ext 0 1e-10
CD1_ESD Vm_Ext 0 1e-12
RD1_LEAK Vm_Ext 0 1G

* ---- Threshold comparator U6B and AP/spike generation ----
* Ground truth: R6=24.3k VDD->V_Threshold, R7=10k V_Threshold->GNDREF.
R6 VDD V_Threshold 24300
R7 V_Threshold 0 10000
* U6B: INB+=V_Threshold, INB-=Vm_Int, OUTB=/Threshold_Comparator_Out.
R33 V_Threshold Threshold_Comparator_Out 220000
R34 VDD Threshold_Comparator_Out 10000
SU6B Threshold_Comparator_Out 0 Vm_Int V_Threshold SW_OC
* Q1=BSS138: D=AP, G=/Threshold_Comparator_Out, S=GNDREF.
R35 VDD AP 22000
MQ1 AP Threshold_Comparator_Out 0 0 BSS138_FALLBACK
* C29=10nF AP->/Rising_AP, R46=100k /Rising_AP->GNDREF, D8=RB521S30T1G to Spike_Pulse.
C29 AP Rising_AP 1e-08
R46 Rising_AP 0 100000
DD8 Rising_AP Spike_Pulse RB521S30_FALLBACK
R47 Spike_Pulse 0 1000000
* D20 external Schottky clamp added to schematic: anode=GNDREF, cathode=Spike_Pulse.
* It conducts when Spike_Pulse goes below GNDREF and protects U6A INA+.
DD20 0 Spike_Pulse RB521S30_FALLBACK

* ---- Peak and reset windows: U6A/U6C and Q3-Q6 ----
* U6A: INA+=Spike_Pulse, INA-=V_Threshold, OUTA=Peak_Window; R48 pull-up.
* Fallback open-drain comparator pulls OUT low when V(-) > V(+).
R48 VDD Peak_Window 100000
SU6A Peak_Window 0 V_Threshold Spike_Pulse SW_OC

* Vm peak-injection path: U14 closes when Peak_Window is high.
* Hardware: U2C buffered V_Peak_Ref -> R49 -> U14 NO/COM -> Vm_Int.
R49 V_Peak_Drive Peak_Injection_NO 10000
SU14_PEAK Vm_Int Peak_Injection_NO Peak_Window 0 SW_TS5A3166

* Reset-window timing node: R50=22k VDD->Net-(U6C-INC-), C31=1uF to GNDREF.
R50 VDD U6C_INC_minus 22000
C31 U6C_INC_minus 0 1e-06 IC=3
* Q3=BSS138: D=Reset_Timer_Discharge, G=AP, S=GNDREF; R51=100R from RESET_TIMER_DISCHARGE to U6C_MINUS.
MQ3 Reset_Timer_Discharge AP 0 0 BSS138_FALLBACK
R51 Reset_Timer_Discharge U6C_INC_minus 100

* U6C plus input network and reset-window pull-up.
R53 U6C_INC_plus VDD 27000
R54 U6C_INC_plus Reset_Window 100000
R55 U6C_INC_plus 0 22000
R52 VDD Reset_Window 100000
SU6C Reset_Window 0 U6C_INC_minus U6C_INC_plus SW_OC

* Reset-current gate chain Q4/Q5/Q6.
* Q4=BSS138: D=/Reset_Injection_Enable, G=Peak_Window, S=GNDREF; R56 pull-up.
R56 VDD Reset_Injection_Enable 100000
MQ4 Reset_Injection_Enable Peak_Window 0 0 BSS138_FALLBACK
* Q5=BSS138: G=/Reset_Injection_Enable, S=/Reset_Injection_Drive, D=Reset_Ref_Gated.
MQ5 Reset_Ref_Gated Reset_Injection_Enable Reset_Injection_Drive Reset_Injection_Drive BSS138_FALLBACK
* Q6=BSS138: G=Reset_Window, S=Reset_Ref_Gated, D=Reset_Current_Node; R57=10k to Vm_Int.
MQ6 Reset_Current_Node Reset_Window Reset_Ref_Gated Reset_Ref_Gated BSS138_FALLBACK
R57 Reset_Current_Node Vm_Int 10000

* Spike_Out driver: U6D compares Peak_Window against V_Logic_Mid; R81 pull-up and R82 series output.
* V_Logic_Mid is approximated with the schematic divider R12/R13 already used by U6D.
R12_LOGIC VDD V_Logic_Mid 100000
R13_LOGIC V_Logic_Mid 0 100000
R81 VDD U6D_Out 100000
SU6D_SPIKE_OUT U6D_Out 0 V_Logic_Mid Peak_Window SW_OC
R82 U6D_Out Spike_Out 100
CD18_ESD Spike_Out 0 1e-12
RD18_LEAK Spike_Out 0 1G

* ---- Adaptation path /Vw ----
* U1B adaptation-shaping amplifier from schematic, implemented as a closed-loop equivalent.
* This keeps the R37/R38/R39/R40 loading while avoiding an ideal op-amp feedback loop at t=0.
R37 Vkick Adapt_U1B_plus 200000
R38 Adapt_U1B_plus Vm_Int 100000
R39 V_Leak Adapt_U1B_minus 100000
R40 Adapt_U1B_minus Adapt_U1B_out 200000
BU1B_ADAPT_CL U1B_ADAPT_CL_raw 0 V={ min(max((3*V(Adapt_U1B_plus)-2*V(V_Leak)),0),V(VDD)) }
RU1B_ADAPT_CL_OUT U1B_ADAPT_CL_raw Adapt_U1B_out 100
R41 Adapt_U1B_out Adapt_U1B_diode_A 330000
DD6 Adapt_U1B_diode_A Vw RB521S30_FALLBACK
* U1C is a follower driven from AP: U1C+=AP, U1C-/OUT=Adapt_Kick_Drive.
EU1C U1C_ideal_out 0 AP 0 1
* Model-only U1C output resistance/current-limiting approximation.
* This prevents the ideal fallback op-amp from injecting unrealistic current into C27.
RU1C_OUT U1C_ideal_out Adapt_Kick_Drive 100
* C27=1uF between U1C output and /Vkick; R36=22k /Vkick->GNDREF.
C27 Vkick Adapt_Kick_Drive 1e-06
R36 Vkick 0 22000
* Diode orientation from KiCad pins: D4 GNDREF->/Vkick, D5 /Vkick->Vw, D7 GNDREF->Vw.
DD4 0 Vkick D1N4148_FALLBACK
DD5 Vkick Vw D1N4148_FALLBACK
DD7 0 Vw D1N4148_FALLBACK
C28 Vw 0 1e-05 IC=0
* RV3=100k: pins 1/2=Vw, pin3=Net-(R42-Pad1); requested fraction=0.800, effective fraction=0.800.
RV3_LOWER Vw Vw 80000
RV3_UPPER Vw RV3_bottom 20000
R42 RV3_bottom 0 100
EU1D Vw_buff 0 Vw 0 1
* Q2=MMBT3904 adaptation current path: R44/R45 base divider, R43 collector to Vm_Int.
R44 Vw_buff Adapt_Base 22000
R45 Adapt_Base 0 100000
Q2 Adapt_Current_Sink Adapt_Base 0 MMBT3904_FALLBACK
R43 Vm_Int Adapt_Current_Sink 10000

* ---- Synaptic state and spike-gated input circuit ----
* C36/R79/RV5 form the synaptic state memory/decay path.
C36 V_Syn_State 0 2.2e-07 IC=0.385
R79 V_Syn_State RV5_decay 10000
RV5_DECAY_RES RV5_decay V_Leak 50000
* Intended U2D follower: V_Syn_State -> V_Syn_Drive; R80 injects into Vm_Int.
EU2D_SYN V_Syn_Drive 0 V_Syn_State 0 1
R80 V_Syn_Drive Vm_Int 47000

* Current KiCad reference connectivity already modeled in the passive/reference block:
* R4/R5 -> V_Leak_Ref_Max_Raw -> U2A buffer -> V_Leak_Ref_Max.
* RV6, RV7, RV8 and RV9 pin 3 are connected to buffered V_Leak_Ref_Max.
* RV6=100k: pin1=GNDREF, pin2=Syn1 set wiper, pin3=V_Leak_Ref_Max.
* Syn1 set requested fraction=1.000, effective fraction=1.000
RV6_LOW Syn1_Set_raw 0 99999.9
RV6_HIGH V_Leak_Ref_Max Syn1_Set_raw 0.100000000003
EU3B V_Syn1_Set 0 Syn1_Set_raw 0 1
* RV7=100k: pin1=GNDREF, pin2=Syn2 set wiper, pin3=V_Leak_Ref_Max.
* Syn2 set requested fraction=1.000, effective fraction=1.000
RV7_LOW Syn2_Set_raw 0 99999.9
RV7_HIGH V_Leak_Ref_Max Syn2_Set_raw 0.100000000003
EU3C V_Syn2_Set 0 Syn2_Set_raw 0 1
* RV8=100k: pin1=GNDREF, pin2=Syn3 set wiper, pin3=V_Leak_Ref_Max.
* Syn3 set requested fraction=1.000, effective fraction=1.000
RV8_LOW Syn3_Set_raw 0 99999.9
RV8_HIGH V_Leak_Ref_Max Syn3_Set_raw 0.100000000003
EU3D V_Syn3_Set 0 Syn3_Set_raw 0 1
* RV9=100k: pin1=GNDREF, pin2=Syn4 set wiper, pin3=V_Leak_Ref_Max.
* Syn4 set requested fraction=1.000, effective fraction=1.000
RV9_LOW Syn4_Set_raw 0 99999.9
RV9_HIGH V_Leak_Ref_Max Syn4_Set_raw 0.100000000003
EU3A V_Syn4_Set 0 Syn4_Set_raw 0 1
* Syn1 spike input: jack net -> 22k -> clamp node -> 1k -> TS5A3166 IN.
VSYN1 Syn1_Spike 0 PULSE(0 3 150m 1u 1u 5m 100m)
R66 Syn1_Spike Syn1_Input 22000
R65 Syn1_Input 0 100000
DD10 Syn1_Input VDD BAT54_FALLBACK
DD11 0 Syn1_Input BAT54_FALLBACK
R64 Syn1_Input U15_IN 1000
* U15=TS5A3166: COM=V_Syn1_Set, NO=Net-(U15-NO), IN=Syn1 control.
SU15 V_Syn1_Set Syn1_NO U15_IN 0 SW_TS5A3166
R63 Syn1_NO V_Syn_State 22000
* Syn2 spike input: jack net -> 22k -> clamp node -> 1k -> TS5A3166 IN.
VSYN2 Syn2_Spike 0 PULSE(0 3 150m 1u 1u 5m 100m)
R70 Syn2_Spike Syn2_Input 22000
R69 Syn2_Input 0 100000
DD12 Syn2_Input VDD BAT54_FALLBACK
DD13 0 Syn2_Input BAT54_FALLBACK
R68 Syn2_Input U16_IN 1000
* U16=TS5A3166: COM=V_Syn2_Set, NO=Net-(U16-NO), IN=Syn2 control.
SU16 V_Syn2_Set Syn2_NO U16_IN 0 SW_TS5A3166
R67 Syn2_NO V_Syn_State 22000
* Syn3 spike input: jack net -> 22k -> clamp node -> 1k -> TS5A3166 IN.
VSYN3 Syn3_Spike 0 PULSE(0 3 150m 1u 1u 5m 100m)
R74 Syn3_Spike Syn3_Input 22000
R73 Syn3_Input 0 100000
DD14 Syn3_Input VDD BAT54_FALLBACK
DD15 0 Syn3_Input BAT54_FALLBACK
R72 Syn3_Input U17_IN 1000
* U17=TS5A3166: COM=V_Syn3_Set, NO=Net-(U17-NO), IN=Syn3 control.
SU17 V_Syn3_Set Syn3_NO U17_IN 0 SW_TS5A3166
R71 Syn3_NO V_Syn_State 22000
* Syn4 spike input: jack net -> 22k -> clamp node -> 1k -> TS5A3166 IN.
VSYN4 Syn4_Spike 0 PULSE(0 3 150m 1u 1u 5m 100m)
R78 Syn4_Spike Syn4_Input 22000
R77 Syn4_Input 0 100000
DD16 Syn4_Input VDD BAT54_FALLBACK
DD17 0 Syn4_Input BAT54_FALLBACK
R76 Syn4_Input U18_IN 1000
* U18=TS5A3166: COM=V_Syn4_Set, NO=Net-(U18-NO), IN=Syn4 control.
SU18 V_Syn4_Set Syn4_NO U18_IN 0 SW_TS5A3166
R75 Syn4_NO V_Syn_State 22000

* ---- Analysis ----
.tran 1u 1.5 0 1u uic
.save V(Vm_Ext) V(Vm_Int) V(V_Leak) V(VDD) V(V_Threshold) V(AP) V(Spike_Pulse) V(Spike_Out) V(Peak_Window) V(Reset_Window) V(Vw) V(Vw_buff) V(V_Syn_State) V(Syn1_Spike) V(V_Syn1_Set) V(Syn2_Spike) V(V_Syn2_Set) V(Syn3_Spike) V(V_Syn3_Set) V(Syn4_Spike) V(V_Syn4_Set)
.control
run
wrdata C:/Users/mzimm/Documents/GitHub/Spiky-Lu.i/SPICE/spiky_pyspice_output/spiky_vm_trac_r0p7-0p5-0p8_m0p3c1u_b3r50_op_i20_s1234k0p5g1_d150m_w5m_t1p5_hedcd1ea7.csv v(Vm_Ext) v(Vm_Int) v(V_Leak) v(VDD) v(V_Threshold) v(AP) v(Spike_Pulse) v(Spike_Out) v(Peak_Window) v(Reset_Window) v(Vw) v(Vw_buff) v(V_Syn_State) v(Syn1_Spike) v(V_Syn1_Set) v(Syn2_Spike) v(V_Syn2_Set) v(Syn3_Spike) v(V_Syn3_Set) v(Syn4_Spike) v(V_Syn4_Set)
quit
.endc
.end
